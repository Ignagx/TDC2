* ============================================================================
* TP2 Teoria de Circuitos II - Grupo 2 (Ernst, Gil, Rao)
* Filtro Pasa Bajos Activo Orden 4 - Aproximacion Butterworth - Sallen-Key
* Especificaciones: Amax = 1.5 dB @ fp = 5.5 kHz | Ganancia K = 4 V/V (12.04 dB)
* Comparacion: (1) Ideal Teorico, (2) Comercial + AO Ideal, (3) Comercial + TL084 Real
* ============================================================================

.include "TL084.lib"

* Subcircuito de Amplificador Operacional Ideal (alta ganancia DC, ancho de banda infinito)
.SUBCKT OPAMP_IDEAL 1 2 5
  RIN 1 2 1e12
  E1  5 0 1 2 1e7
.ENDS OPAMP_IDEAL

* Alimentacion simetrica +/-15V (y +/-12V para verificacion)
VCC  vcc  0 DC 15
VEE  vee  0 DC -15
VCC12 vcc12 0 DC 12
VEE12 vee12 0 DC -12

* Fuente de excitacion AC (1 V amplitud = 0 dBV, de modo que V(out) = H(jw))
VIN  in   0 DC 0 AC 1

* ----------------------------------------------------------------------------
* CIRCUITO 1: IDEAL EXACTO (Valores calculados sin redondear + AO Ideal)
* Etapa 1: Q1 = 0.541196, f0 = 6143.6965 Hz, G1 = 2
*   C1 = 2.2 nF, C2 = 3.3 nF => R1 = 3899.07 Ohm, R2 = 23707.18 Ohm, Ra1=Rb1=10k
* Etapa 2: Q2 = 1.306563, f0 = 6143.6965 Hz, G2 = 2
*   C3 = 3.3 nF, C4 = 10.0 nF => R3 = 2013.99 Ohm, R4 = 10097.28 Ohm, Ra2=Rb2=10k
* ----------------------------------------------------------------------------
R1_id  in     n1_id   3899.07
R2_id  n1_id  n2_id   23707.18
C1_id  n2_id  0       2.2n
C2_id  out1_id n1_id  3.3n
RA1_id inv1_id 0      10k
RB1_id out1_id inv1_id 10k
XU1_id n2_id  inv1_id out1_id OPAMP_IDEAL

R3_id  out1_id n3_id  2013.99
R4_id  n3_id  n4_id   10097.28
C3_id  n4_id  0       3.3n
C4_id  out_id n3_id   10n
RA2_id inv2_id 0      10k
RB2_id out_id inv2_id 10k
XU2_id n4_id  inv2_id out_id OPAMP_IDEAL

* ----------------------------------------------------------------------------
* CIRCUITO 2: ELEMENTOS COMERCIALES (E24 1% / Poliester E6) + AO IDEAL
* Etapa 1: R1 = 3.9 kOhm, R2 = 24 kOhm, C1 = 2.2 nF, C2 = 3.3 nF, Ra1=Rb1=10 kOhm
* Etapa 2: R3 = 2.0 kOhm, R4 = 10 kOhm, C3 = 3.3 nF, C4 = 10 nF,  Ra2=Rb2=10 kOhm
* ----------------------------------------------------------------------------
R1_ci  in     n1_ci   3.9k
R2_ci  n1_ci  n2_ci   24k
C1_ci  n2_ci  0       2.2n
C2_ci  out1_ci n1_ci  3.3n
RA1_ci inv1_ci 0      10k
RB1_ci out1_ci inv1_ci 10k
XU1_ci n2_ci  inv1_ci out1_ci OPAMP_IDEAL

R3_ci  out1_ci n3_ci  2.0k
R4_ci  n3_ci  n4_ci   10k
C3_ci  n4_ci  0       3.3n
C4_ci  out_ci n3_ci   10n
RA2_ci inv2_ci 0      10k
RB2_ci out_ci inv2_ci 10k
XU2_ci n4_ci  inv2_ci out_ci OPAMP_IDEAL

* ----------------------------------------------------------------------------
* CIRCUITO 3: ELEMENTOS COMERCIALES + MODELO REAL TL084 (+/-15V, Rload=10k)
* ----------------------------------------------------------------------------
R1_re  in     n1_re   3.9k
R2_re  n1_re  n2_re   24k
C1_re  n2_re  0       2.2n
C2_re  out1_re n1_re  3.3n
RA1_re inv1_re 0      10k
RB1_re out1_re inv1_re 10k
XU1_re n2_re  inv1_re vcc vee out1_re TL084

R3_re  out1_re n3_re  2.0k
R4_re  n3_re  n4_re   10k
C3_re  n4_re  0       3.3n
C4_re  out_re n3_re   10n
RA2_re inv2_re 0      10k
RB2_re out_re inv2_re 10k
XU2_re n4_re  inv2_re vcc vee out_re TL084
RL_re  out_re 0       100k

* ----------------------------------------------------------------------------
* CIRCUITO 4: ELEMENTOS COMERCIALES + MODELO REAL TL084 (+/-12V)
* ----------------------------------------------------------------------------
R1_12  in     n1_12   3.9k
R2_12  n1_12  n2_12   24k
C1_12  n2_12  0       2.2n
C2_12  out1_12 n1_12  3.3n
RA1_12 inv1_12 0      10k
RB1_12 out1_12 inv1_12 10k
XU1_12 n2_12  inv1_12 vcc12 vee12 out1_12 TL084

R3_12  out1_12 n3_12  2.0k
R4_12  n3_12  n4_12   10k
C3_12  n4_12  0       3.3n
C4_12  out_12 n3_12   10n
RA2_12 inv2_12 0      10k
RB2_12 out_12 inv2_12 10k
XU2_12 n4_12  inv2_12 vcc12 vee12 out_12 TL084
RL_12  out_12 0       100k

.control
set wr_vecnames
set wr_singlescale
ac dec 1000 10 10Meg

let mag_id = vdb(out_id)
let pha_id = cph(out_id)*180/pi
let mag_ci = vdb(out_ci)
let pha_ci = cph(out_ci)*180/pi
let mag_re = vdb(out_re)
let pha_re = cph(out_re)*180/pi
let mag_st1 = vdb(out1_re)
let mag_12 = vdb(out_12)

wrdata bode_ngspice.dat mag_id pha_id mag_ci pha_ci mag_re pha_re mag_st1 mag_12

echo "=== MEDICIONES EXACTAS EN NGSPICE ==="
meas ac id_dc    find mag_id at=10
meas ac id_fp    find mag_id at=5500
let target_id = id_dc - 3.0103
meas ac id_f3db  when mag_id=target_id
meas ac id_2fp   find mag_id at=11000
meas ac id_10fp  find mag_id at=55000

meas ac ci_dc    find mag_ci at=10
meas ac ci_fp    find mag_ci at=5500
let target_ci = ci_dc - 3.0103
meas ac ci_f3db  when mag_ci=target_ci
meas ac ci_2fp   find mag_ci at=11000
meas ac ci_10fp  find mag_ci at=55000

meas ac re_dc    find mag_re at=10
meas ac re_fp    find mag_re at=5500
let target_re = re_dc - 3.0103
meas ac re_f3db  when mag_re=target_re
meas ac re_2fp   find mag_re at=11000
meas ac re_10fp  find mag_re at=55000
meas ac re_100k  find mag_re at=100000
meas ac re_min   min  mag_re from=10k to=10Meg

quit
.endc
.END
