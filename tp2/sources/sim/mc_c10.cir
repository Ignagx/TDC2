* Monte Carlo SPICE con modelo real TL084
.include "TL084.lib"
VCC vcc 0 DC 15
VEE vee 0 DC -15
VIN in 0 DC 0 AC 1
R1_0 in n1_0 3888.0104
R2_0 n1_0 n2_0 23972.9548
C1_0 n2_0 0 2.338932e-09
C2_0 o1_0 n1_0 3.423745e-09
RA1_0 iv1_0 0 9960.0852
RB1_0 o1_0 iv1_0 9988.0283
XU1_0 n2_0 iv1_0 vcc vee o1_0 TL084
R3_0 o1_0 n3_0 2002.5404
R4_0 n3_0 n4_0 10067.3478
C3_0 n4_0 0 3.110183e-09
C4_0 out_0 n3_0 1.082901e-08
RA2_0 iv2_0 0 9963.0809
RB2_0 out_0 iv2_0 10055.6514
XU2_0 n4_0 iv2_0 vcc vee out_0 TL084
R1_1 in n1_1 3901.9299
R2_1 n1_1 n2_1 23927.4800
C1_1 n2_1 0 2.225214e-09
C2_1 o1_1 n1_1 3.290672e-09
RA1_1 iv1_1 0 9930.4943
RB1_1 o1_1 iv1_1 9989.4965
XU1_1 n2_1 iv1_1 vcc vee o1_1 TL084
R3_1 o1_1 n3_1 2017.1137
R4_1 n3_1 n4_1 10031.6358
C3_1 n4_1 0 3.049169e-09
C4_1 out_1 n3_1 1.040292e-08
RA2_1 iv2_1 0 10039.8775
RB2_1 out_1 iv2_1 9998.9880
XU2_1 n4_1 iv2_1 vcc vee out_1 TL084
R1_2 in n1_2 3863.2933
R2_2 n1_2 n2_2 24026.0732
C1_2 n2_2 0 2.104231e-09
C2_2 o1_2 n1_2 3.328188e-09
RA1_2 iv1_2 0 9976.0594
RB1_2 o1_2 iv1_2 9980.5147
XU1_2 n2_2 iv1_2 vcc vee o1_2 TL084
R3_2 o1_2 n3_2 2017.5005
R4_2 n3_2 n4_2 10088.8129
C3_2 n4_2 0 3.083827e-09
C4_2 out_2 n3_2 9.493745e-09
RA2_2 iv2_2 0 10096.8961
RB2_2 out_2 iv2_2 10011.1974
XU2_2 n4_2 iv2_2 vcc vee out_2 TL084
R1_3 in n1_3 3914.6544
R2_3 n1_3 n2_3 24042.3402
C1_3 n2_3 0 2.033783e-09
C2_3 o1_3 n1_3 3.334833e-09
RA1_3 iv1_3 0 9908.6325
RB1_3 o1_3 iv1_3 9900.2059
XU1_3 n2_3 iv1_3 vcc vee o1_3 TL084
R3_3 o1_3 n3_3 1980.7891
R4_3 n3_3 n4_3 10000.6720
C3_3 n4_3 0 3.028880e-09
C4_3 out_3 n3_3 9.070230e-09
RA2_3 iv2_3 0 9919.3335
RB2_3 out_3 iv2_3 10004.8320
XU2_3 n4_3 iv2_3 vcc vee out_3 TL084
R1_4 in n1_4 3910.3353
R2_4 n1_4 n2_4 23863.4397
C1_4 n2_4 0 2.382636e-09
C2_4 o1_4 n1_4 3.090065e-09
RA1_4 iv1_4 0 9986.6254
RB1_4 o1_4 iv1_4 10027.9850
XU1_4 n2_4 iv1_4 vcc vee o1_4 TL084
R3_4 o1_4 n3_4 2004.9641
R4_4 n3_4 n4_4 9941.0004
C3_4 n4_4 0 3.099917e-09
C4_4 out_4 n3_4 9.513063e-09
RA2_4 iv2_4 0 10013.3065
RB2_4 out_4 iv2_4 10067.7220
XU2_4 n4_4 iv2_4 vcc vee out_4 TL084
R1_5 in n1_5 3874.5156
R2_5 n1_5 n2_5 23994.1816
C1_5 n2_5 0 2.077081e-09
C2_5 o1_5 n1_5 3.484703e-09
RA1_5 iv1_5 0 9979.0695
RB1_5 o1_5 iv1_5 9930.8901
XU1_5 n2_5 iv1_5 vcc vee o1_5 TL084
R3_5 o1_5 n3_5 2006.9034
R4_5 n3_5 n4_5 10007.9384
C3_5 n4_5 0 3.408338e-09
C4_5 out_5 n3_5 9.436144e-09
RA2_5 iv2_5 0 9952.9716
RB2_5 out_5 iv2_5 9964.3270
XU2_5 n4_5 iv2_5 vcc vee out_5 TL084
R1_6 in n1_6 3926.8226
R2_6 n1_6 n2_6 23899.2950
C1_6 n2_6 0 2.283108e-09
C2_6 o1_6 n1_6 3.384868e-09
RA1_6 iv1_6 0 10034.1997
RB1_6 o1_6 iv1_6 9988.5294
XU1_6 n2_6 iv1_6 vcc vee o1_6 TL084
R3_6 o1_6 n3_6 2010.2082
R4_6 n3_6 n4_6 9996.2929
C3_6 n4_6 0 3.141112e-09
C4_6 out_6 n3_6 9.998064e-09
RA2_6 iv2_6 0 10037.2857
RB2_6 out_6 iv2_6 9923.8373
XU2_6 n4_6 iv2_6 vcc vee out_6 TL084
R1_7 in n1_7 3917.9580
R2_7 n1_7 n2_7 24004.5592
C1_7 n2_7 0 2.377797e-09
C2_7 o1_7 n1_7 3.315882e-09
RA1_7 iv1_7 0 10076.3574
RB1_7 o1_7 iv1_7 9935.6561
XU1_7 n2_7 iv1_7 vcc vee o1_7 TL084
R3_7 o1_7 n3_7 1985.3616
R4_7 n3_7 n4_7 9998.6573
C3_7 n4_7 0 2.972388e-09
C4_7 out_7 n3_7 9.991402e-09
RA2_7 iv2_7 0 9921.0891
RB2_7 out_7 iv2_7 10066.5400
XU2_7 n4_7 iv2_7 vcc vee out_7 TL084
R1_8 in n1_8 3920.4050
R2_8 n1_8 n2_8 23977.2049
C1_8 n2_8 0 2.036511e-09
C2_8 o1_8 n1_8 3.505996e-09
RA1_8 iv1_8 0 10099.4535
RB1_8 o1_8 iv1_8 10002.7625
XU1_8 n2_8 iv1_8 vcc vee o1_8 TL084
R3_8 o1_8 n3_8 1993.4440
R4_8 n3_8 n4_8 9982.1272
C3_8 n4_8 0 3.492097e-09
C4_8 out_8 n3_8 9.399918e-09
RA2_8 iv2_8 0 9934.1898
RB2_8 out_8 iv2_8 9941.4251
XU2_8 n4_8 iv2_8 vcc vee out_8 TL084
R1_9 in n1_9 3927.5057
R2_9 n1_9 n2_9 24112.9127
C1_9 n2_9 0 2.397985e-09
C2_9 o1_9 n1_9 3.581137e-09
RA1_9 iv1_9 0 10011.1914
RB1_9 o1_9 iv1_9 9950.7122
XU1_9 n2_9 iv1_9 vcc vee o1_9 TL084
R3_9 o1_9 n3_9 2005.5778
R4_9 n3_9 n4_9 10070.8148
C3_9 n4_9 0 3.521922e-09
C4_9 out_9 n3_9 9.054417e-09
RA2_9 iv2_9 0 10097.3314
RB2_9 out_9 iv2_9 9989.3556
XU2_9 n4_9 iv2_9 vcc vee out_9 TL084
R1_10 in n1_10 3879.2437
R2_10 n1_10 n2_10 23895.2005
C1_10 n2_10 0 2.392570e-09
C2_10 o1_10 n1_10 3.170069e-09
RA1_10 iv1_10 0 9981.2863
RB1_10 o1_10 iv1_10 9926.1853
XU1_10 n2_10 iv1_10 vcc vee o1_10 TL084
R3_10 o1_10 n3_10 1998.6631
R4_10 n3_10 n4_10 10029.1259
C3_10 n4_10 0 3.279910e-09
C4_10 out_10 n3_10 9.646119e-09
RA2_10 iv2_10 0 10019.2164
RB2_10 out_10 iv2_10 9977.1502
XU2_10 n4_10 iv2_10 vcc vee out_10 TL084
R1_11 in n1_11 3888.8475
R2_11 n1_11 n2_11 23916.5200
C1_11 n2_11 0 2.179572e-09
C2_11 o1_11 n1_11 3.269973e-09
RA1_11 iv1_11 0 10093.2147
RB1_11 o1_11 iv1_11 9938.2134
XU1_11 n2_11 iv1_11 vcc vee o1_11 TL084
R3_11 o1_11 n3_11 2013.9517
R4_11 n3_11 n4_11 10055.2668
C3_11 n4_11 0 3.500207e-09
C4_11 out_11 n3_11 1.086357e-08
RA2_11 iv2_11 0 9941.4276
RB2_11 out_11 iv2_11 10096.5071
XU2_11 n4_11 iv2_11 vcc vee out_11 TL084
R1_12 in n1_12 3888.6744
R2_12 n1_12 n2_12 24239.8430
C1_12 n2_12 0 2.107522e-09
C2_12 o1_12 n1_12 3.150087e-09
RA1_12 iv1_12 0 9995.5331
RB1_12 o1_12 iv1_12 10017.8648
XU1_12 n2_12 iv1_12 vcc vee o1_12 TL084
R3_12 o1_12 n3_12 1983.2071
R4_12 n3_12 n4_12 9945.0622
C3_12 n4_12 0 3.405760e-09
C4_12 out_12 n3_12 1.030815e-08
RA2_12 iv2_12 0 10014.5923
RB2_12 out_12 iv2_12 10011.0563
XU2_12 n4_12 iv2_12 vcc vee out_12 TL084
R1_13 in n1_13 3918.3707
R2_13 n1_13 n2_13 24193.8135
C1_13 n2_13 0 2.089457e-09
C2_13 o1_13 n1_13 3.321970e-09
RA1_13 iv1_13 0 9990.4350
RB1_13 o1_13 iv1_13 10079.3984
XU1_13 n2_13 iv1_13 vcc vee o1_13 TL084
R3_13 o1_13 n3_13 1995.7970
R4_13 n3_13 n4_13 10064.9325
C3_13 n4_13 0 3.568757e-09
C4_13 out_13 n3_13 1.034620e-08
RA2_13 iv2_13 0 10079.0838
RB2_13 out_13 iv2_13 10057.2727
XU2_13 n4_13 iv2_13 vcc vee out_13 TL084
R1_14 in n1_14 3920.7110
R2_14 n1_14 n2_14 23836.2677
C1_14 n2_14 0 2.026065e-09
C2_14 o1_14 n1_14 3.121105e-09
RA1_14 iv1_14 0 9990.4004
RB1_14 o1_14 iv1_14 9980.7453
XU1_14 n2_14 iv1_14 vcc vee o1_14 TL084
R3_14 o1_14 n3_14 1985.7211
R4_14 n3_14 n4_14 10013.1673
C3_14 n4_14 0 3.340863e-09
C4_14 out_14 n3_14 9.232277e-09
RA2_14 iv2_14 0 9938.4042
RB2_14 out_14 iv2_14 10061.7888
XU2_14 n4_14 iv2_14 vcc vee out_14 TL084
R1_15 in n1_15 3877.4480
R2_15 n1_15 n2_15 24079.0413
C1_15 n2_15 0 2.328155e-09
C2_15 o1_15 n1_15 3.108429e-09
RA1_15 iv1_15 0 9912.7418
RB1_15 o1_15 iv1_15 10073.5682
XU1_15 n2_15 iv1_15 vcc vee o1_15 TL084
R3_15 o1_15 n3_15 2013.6004
R4_15 n3_15 n4_15 9931.6247
C3_15 n4_15 0 3.613260e-09
C4_15 out_15 n3_15 1.063669e-08
RA2_15 iv2_15 0 10046.4742
RB2_15 out_15 iv2_15 9961.1510
XU2_15 n4_15 iv2_15 vcc vee out_15 TL084
R1_16 in n1_16 3887.1159
R2_16 n1_16 n2_16 23914.6841
C1_16 n2_16 0 2.080163e-09
C2_16 o1_16 n1_16 3.342203e-09
RA1_16 iv1_16 0 10060.5520
RB1_16 o1_16 iv1_16 9995.5785
XU1_16 n2_16 iv1_16 vcc vee o1_16 TL084
R3_16 o1_16 n3_16 1993.3665
R4_16 n3_16 n4_16 10052.0423
C3_16 n4_16 0 3.291984e-09
C4_16 out_16 n3_16 9.578992e-09
RA2_16 iv2_16 0 10083.5190
RB2_16 out_16 iv2_16 10084.8339
XU2_16 n4_16 iv2_16 vcc vee out_16 TL084
R1_17 in n1_17 3900.3907
R2_17 n1_17 n2_17 23960.9656
C1_17 n2_17 0 2.067723e-09
C2_17 o1_17 n1_17 3.393226e-09
RA1_17 iv1_17 0 10010.8798
RB1_17 o1_17 iv1_17 9906.7201
XU1_17 n2_17 iv1_17 vcc vee o1_17 TL084
R3_17 o1_17 n3_17 2018.2514
R4_17 n3_17 n4_17 9918.0274
C3_17 n4_17 0 3.162913e-09
C4_17 out_17 n3_17 1.004253e-08
RA2_17 iv2_17 0 9913.5507
RB2_17 out_17 iv2_17 10087.1925
XU2_17 n4_17 iv2_17 vcc vee out_17 TL084
R1_18 in n1_18 3917.7360
R2_18 n1_18 n2_18 24075.6440
C1_18 n2_18 0 2.279743e-09
C2_18 o1_18 n1_18 3.585465e-09
RA1_18 iv1_18 0 10079.9407
RB1_18 o1_18 iv1_18 9915.5812
XU1_18 n2_18 iv1_18 vcc vee o1_18 TL084
R3_18 o1_18 n3_18 1987.5601
R4_18 n3_18 n4_18 9926.0429
C3_18 n4_18 0 3.161888e-09
C4_18 out_18 n3_18 1.038513e-08
RA2_18 iv2_18 0 9972.0096
RB2_18 out_18 iv2_18 10017.0101
XU2_18 n4_18 iv2_18 vcc vee out_18 TL084
R1_19 in n1_19 3908.6302
R2_19 n1_19 n2_19 23989.9723
C1_19 n2_19 0 2.170742e-09
C2_19 o1_19 n1_19 3.505991e-09
RA1_19 iv1_19 0 10081.7378
RB1_19 o1_19 iv1_19 10049.6345
XU1_19 n2_19 iv1_19 vcc vee o1_19 TL084
R3_19 o1_19 n3_19 2000.5332
R4_19 n3_19 n4_19 9927.2605
C3_19 n4_19 0 3.050644e-09
C4_19 out_19 n3_19 1.023117e-08
RA2_19 iv2_19 0 10025.4253
RB2_19 out_19 iv2_19 9922.4670
XU2_19 n4_19 iv2_19 vcc vee out_19 TL084
R1_20 in n1_20 3931.9948
R2_20 n1_20 n2_20 24066.2791
C1_20 n2_20 0 2.033065e-09
C2_20 o1_20 n1_20 3.555802e-09
RA1_20 iv1_20 0 10078.1198
RB1_20 o1_20 iv1_20 10028.9452
XU1_20 n2_20 iv1_20 vcc vee o1_20 TL084
R3_20 o1_20 n3_20 2012.1334
R4_20 n3_20 n4_20 10011.4961
C3_20 n4_20 0 3.283591e-09
C4_20 out_20 n3_20 1.066844e-08
RA2_20 iv2_20 0 9962.3223
RB2_20 out_20 iv2_20 9958.3271
XU2_20 n4_20 iv2_20 vcc vee out_20 TL084
R1_21 in n1_21 3931.7023
R2_21 n1_21 n2_21 24116.1991
C1_21 n2_21 0 2.019340e-09
C2_21 o1_21 n1_21 3.044969e-09
RA1_21 iv1_21 0 9950.4337
RB1_21 o1_21 iv1_21 10074.1407
XU1_21 n2_21 iv1_21 vcc vee o1_21 TL084
R3_21 o1_21 n3_21 2008.1145
R4_21 n3_21 n4_21 10046.5181
C3_21 n4_21 0 3.288924e-09
C4_21 out_21 n3_21 9.784779e-09
RA2_21 iv2_21 0 9988.9791
RB2_21 out_21 iv2_21 10002.9599
XU2_21 n4_21 iv2_21 vcc vee out_21 TL084
R1_22 in n1_22 3874.3061
R2_22 n1_22 n2_22 23786.8049
C1_22 n2_22 0 2.415876e-09
C2_22 o1_22 n1_22 3.080294e-09
RA1_22 iv1_22 0 9969.5617
RB1_22 o1_22 iv1_22 10052.2248
XU1_22 n2_22 iv1_22 vcc vee o1_22 TL084
R3_22 o1_22 n3_22 1992.1985
R4_22 n3_22 n4_22 10020.5121
C3_22 n4_22 0 3.476620e-09
C4_22 out_22 n3_22 9.124730e-09
RA2_22 iv2_22 0 9937.8289
RB2_22 out_22 iv2_22 10036.2690
XU2_22 n4_22 iv2_22 vcc vee out_22 TL084
R1_23 in n1_23 3917.0902
R2_23 n1_23 n2_23 24075.1696
C1_23 n2_23 0 2.331763e-09
C2_23 o1_23 n1_23 3.214395e-09
RA1_23 iv1_23 0 10007.7899
RB1_23 o1_23 iv1_23 9960.9250
XU1_23 n2_23 iv1_23 vcc vee o1_23 TL084
R3_23 o1_23 n3_23 1999.0365
R4_23 n3_23 n4_23 10023.8925
C3_23 n4_23 0 3.513655e-09
C4_23 out_23 n3_23 9.917525e-09
RA2_23 iv2_23 0 10084.8963
RB2_23 out_23 iv2_23 10079.5544
XU2_23 n4_23 iv2_23 vcc vee out_23 TL084
R1_24 in n1_24 3871.0858
R2_24 n1_24 n2_24 23995.7180
C1_24 n2_24 0 2.224081e-09
C2_24 o1_24 n1_24 3.480187e-09
RA1_24 iv1_24 0 9939.7505
RB1_24 o1_24 iv1_24 10077.0706
XU1_24 n2_24 iv1_24 vcc vee o1_24 TL084
R3_24 o1_24 n3_24 2004.7700
R4_24 n3_24 n4_24 9979.8602
C3_24 n4_24 0 3.053931e-09
C4_24 out_24 n3_24 1.078105e-08
RA2_24 iv2_24 0 10003.9971
RB2_24 out_24 iv2_24 10068.1220
XU2_24 n4_24 iv2_24 vcc vee out_24 TL084
R1_25 in n1_25 3876.9923
R2_25 n1_25 n2_25 24060.9702
C1_25 n2_25 0 2.326998e-09
C2_25 o1_25 n1_25 3.196799e-09
RA1_25 iv1_25 0 9902.5950
RB1_25 o1_25 iv1_25 9923.6788
XU1_25 n2_25 iv1_25 vcc vee o1_25 TL084
R3_25 o1_25 n3_25 1988.7110
R4_25 n3_25 n4_25 9997.0183
C3_25 n4_25 0 3.188084e-09
C4_25 out_25 n3_25 1.040055e-08
RA2_25 iv2_25 0 10004.1541
RB2_25 out_25 iv2_25 10060.3397
XU2_25 n4_25 iv2_25 vcc vee out_25 TL084
R1_26 in n1_26 3936.0083
R2_26 n1_26 n2_26 24197.1342
C1_26 n2_26 0 2.036467e-09
C2_26 o1_26 n1_26 3.036349e-09
RA1_26 iv1_26 0 10065.4907
RB1_26 o1_26 iv1_26 9933.1591
XU1_26 n2_26 iv1_26 vcc vee o1_26 TL084
R3_26 o1_26 n3_26 2018.7942
R4_26 n3_26 n4_26 10078.0631
C3_26 n4_26 0 3.339941e-09
C4_26 out_26 n3_26 9.834027e-09
RA2_26 iv2_26 0 10094.4116
RB2_26 out_26 iv2_26 9942.6918
XU2_26 n4_26 iv2_26 vcc vee out_26 TL084
R1_27 in n1_27 3911.4539
R2_27 n1_27 n2_27 23816.0948
C1_27 n2_27 0 1.992247e-09
C2_27 o1_27 n1_27 3.247773e-09
RA1_27 iv1_27 0 9928.3230
RB1_27 o1_27 iv1_27 9985.5874
XU1_27 n2_27 iv1_27 vcc vee o1_27 TL084
R3_27 o1_27 n3_27 2004.8192
R4_27 n3_27 n4_27 10024.2481
C3_27 n4_27 0 3.463973e-09
C4_27 out_27 n3_27 9.777005e-09
RA2_27 iv2_27 0 10042.8842
RB2_27 out_27 iv2_27 10010.1757
XU2_27 n4_27 iv2_27 vcc vee out_27 TL084
R1_28 in n1_28 3898.3507
R2_28 n1_28 n2_28 23827.1173
C1_28 n2_28 0 2.123940e-09
C2_28 o1_28 n1_28 3.295266e-09
RA1_28 iv1_28 0 10011.3134
RB1_28 o1_28 iv1_28 9940.3155
XU1_28 n2_28 iv1_28 vcc vee o1_28 TL084
R3_28 o1_28 n3_28 1981.8704
R4_28 n3_28 n4_28 10052.2844
C3_28 n4_28 0 3.537780e-09
C4_28 out_28 n3_28 9.513146e-09
RA2_28 iv2_28 0 9935.6113
RB2_28 out_28 iv2_28 10030.9208
XU2_28 n4_28 iv2_28 vcc vee out_28 TL084
R1_29 in n1_29 3906.0479
R2_29 n1_29 n2_29 23916.0450
C1_29 n2_29 0 2.275546e-09
C2_29 o1_29 n1_29 3.010901e-09
RA1_29 iv1_29 0 10051.9064
RB1_29 o1_29 iv1_29 9983.2767
XU1_29 n2_29 iv1_29 vcc vee o1_29 TL084
R3_29 o1_29 n3_29 2002.3897
R4_29 n3_29 n4_29 10069.5095
C3_29 n4_29 0 3.622366e-09
C4_29 out_29 n3_29 9.563237e-09
RA2_29 iv2_29 0 9948.9480
RB2_29 out_29 iv2_29 9943.8241
XU2_29 n4_29 iv2_29 vcc vee out_29 TL084
R1_30 in n1_30 3895.4902
R2_30 n1_30 n2_30 24212.5552
C1_30 n2_30 0 2.173965e-09
C2_30 o1_30 n1_30 3.263878e-09
RA1_30 iv1_30 0 9938.4992
RB1_30 o1_30 iv1_30 9969.0444
XU1_30 n2_30 iv1_30 vcc vee o1_30 TL084
R3_30 o1_30 n3_30 2007.0007
R4_30 n3_30 n4_30 9919.9611
C3_30 n4_30 0 3.277078e-09
C4_30 out_30 n3_30 1.022793e-08
RA2_30 iv2_30 0 9906.5428
RB2_30 out_30 iv2_30 10028.6983
XU2_30 n4_30 iv2_30 vcc vee out_30 TL084
R1_31 in n1_31 3925.6104
R2_31 n1_31 n2_31 23956.9973
C1_31 n2_31 0 2.361333e-09
C2_31 o1_31 n1_31 3.609615e-09
RA1_31 iv1_31 0 10027.2429
RB1_31 o1_31 iv1_31 9961.5355
XU1_31 n2_31 iv1_31 vcc vee o1_31 TL084
R3_31 o1_31 n3_31 1999.2671
R4_31 n3_31 n4_31 9996.6178
C3_31 n4_31 0 3.601396e-09
C4_31 out_31 n3_31 9.000752e-09
RA2_31 iv2_31 0 10034.8876
RB2_31 out_31 iv2_31 9960.6117
XU2_31 n4_31 iv2_31 vcc vee out_31 TL084
R1_32 in n1_32 3882.1148
R2_32 n1_32 n2_32 23919.0136
C1_32 n2_32 0 2.396248e-09
C2_32 o1_32 n1_32 2.998873e-09
RA1_32 iv1_32 0 9974.6417
RB1_32 o1_32 iv1_32 10073.8541
XU1_32 n2_32 iv1_32 vcc vee o1_32 TL084
R3_32 o1_32 n3_32 2000.6973
R4_32 n3_32 n4_32 10012.7736
C3_32 n4_32 0 3.483269e-09
C4_32 out_32 n3_32 9.740336e-09
RA2_32 iv2_32 0 10012.7249
RB2_32 out_32 iv2_32 9930.5787
XU2_32 n4_32 iv2_32 vcc vee out_32 TL084
R1_33 in n1_33 3887.6252
R2_33 n1_33 n2_33 24076.8659
C1_33 n2_33 0 2.184789e-09
C2_33 o1_33 n1_33 3.261517e-09
RA1_33 iv1_33 0 9932.1542
RB1_33 o1_33 iv1_33 9976.2157
XU1_33 n2_33 iv1_33 vcc vee o1_33 TL084
R3_33 o1_33 n3_33 2001.9326
R4_33 n3_33 n4_33 10040.5126
C3_33 n4_33 0 3.139317e-09
C4_33 out_33 n3_33 9.890994e-09
RA2_33 iv2_33 0 9993.4649
RB2_33 out_33 iv2_33 9973.0829
XU2_33 n4_33 iv2_33 vcc vee out_33 TL084
R1_34 in n1_34 3879.7557
R2_34 n1_34 n2_34 24052.1307
C1_34 n2_34 0 2.349843e-09
C2_34 o1_34 n1_34 3.363276e-09
RA1_34 iv1_34 0 9994.2446
RB1_34 o1_34 iv1_34 9914.9258
XU1_34 n2_34 iv1_34 vcc vee o1_34 TL084
R3_34 o1_34 n3_34 2014.3655
R4_34 n3_34 n4_34 10086.1946
C3_34 n4_34 0 3.597981e-09
C4_34 out_34 n3_34 1.009186e-08
RA2_34 iv2_34 0 9968.4857
RB2_34 out_34 iv2_34 9923.2526
XU2_34 n4_34 iv2_34 vcc vee out_34 TL084
R1_35 in n1_35 3920.1844
R2_35 n1_35 n2_35 24021.6676
C1_35 n2_35 0 2.044299e-09
C2_35 o1_35 n1_35 3.084454e-09
RA1_35 iv1_35 0 10097.6921
RB1_35 o1_35 iv1_35 10060.2154
XU1_35 n2_35 iv1_35 vcc vee o1_35 TL084
R3_35 o1_35 n3_35 2018.5547
R4_35 n3_35 n4_35 9957.0593
C3_35 n4_35 0 3.456010e-09
C4_35 out_35 n3_35 1.071516e-08
RA2_35 iv2_35 0 10036.2490
RB2_35 out_35 iv2_35 9910.0709
XU2_35 n4_35 iv2_35 vcc vee out_35 TL084
R1_36 in n1_36 3880.8831
R2_36 n1_36 n2_36 24155.4003
C1_36 n2_36 0 2.075096e-09
C2_36 o1_36 n1_36 3.563057e-09
RA1_36 iv1_36 0 10012.2897
RB1_36 o1_36 iv1_36 10061.7675
XU1_36 n2_36 iv1_36 vcc vee o1_36 TL084
R3_36 o1_36 n3_36 1986.6679
R4_36 n3_36 n4_36 9907.0353
C3_36 n4_36 0 3.189057e-09
C4_36 out_36 n3_36 9.732669e-09
RA2_36 iv2_36 0 10019.9794
RB2_36 out_36 iv2_36 9902.9759
XU2_36 n4_36 iv2_36 vcc vee out_36 TL084
R1_37 in n1_37 3934.8152
R2_37 n1_37 n2_37 24140.4672
C1_37 n2_37 0 2.244762e-09
C2_37 o1_37 n1_37 3.392237e-09
RA1_37 iv1_37 0 9925.1633
RB1_37 o1_37 iv1_37 10061.7666
XU1_37 n2_37 iv1_37 vcc vee o1_37 TL084
R3_37 o1_37 n3_37 2010.1075
R4_37 n3_37 n4_37 9986.9835
C3_37 n4_37 0 2.980040e-09
C4_37 out_37 n3_37 9.897386e-09
RA2_37 iv2_37 0 10085.3854
RB2_37 out_37 iv2_37 10010.2195
XU2_37 n4_37 iv2_37 vcc vee out_37 TL084
R1_38 in n1_38 3861.4099
R2_38 n1_38 n2_38 24196.4026
C1_38 n2_38 0 1.990534e-09
C2_38 o1_38 n1_38 3.378236e-09
RA1_38 iv1_38 0 9960.5129
RB1_38 o1_38 iv1_38 10087.8532
XU1_38 n2_38 iv1_38 vcc vee o1_38 TL084
R3_38 o1_38 n3_38 2006.6293
R4_38 n3_38 n4_38 10067.8630
C3_38 n4_38 0 3.016595e-09
C4_38 out_38 n3_38 9.742732e-09
RA2_38 iv2_38 0 9958.2713
RB2_38 out_38 iv2_38 9904.5691
XU2_38 n4_38 iv2_38 vcc vee out_38 TL084
R1_39 in n1_39 3920.7979
R2_39 n1_39 n2_39 23894.1147
C1_39 n2_39 0 1.995644e-09
C2_39 o1_39 n1_39 3.014822e-09
RA1_39 iv1_39 0 10022.2345
RB1_39 o1_39 iv1_39 9903.6105
XU1_39 n2_39 iv1_39 vcc vee o1_39 TL084
R3_39 o1_39 n3_39 1988.1443
R4_39 n3_39 n4_39 10063.3143
C3_39 n4_39 0 3.497636e-09
C4_39 out_39 n3_39 1.037870e-08
RA2_39 iv2_39 0 10001.3389
RB2_39 out_39 iv2_39 9972.4040
XU2_39 n4_39 iv2_39 vcc vee out_39 TL084
R1_40 in n1_40 3922.0727
R2_40 n1_40 n2_40 23773.1160
C1_40 n2_40 0 2.384713e-09
C2_40 o1_40 n1_40 3.603971e-09
RA1_40 iv1_40 0 9944.0196
RB1_40 o1_40 iv1_40 10044.8809
XU1_40 n2_40 iv1_40 vcc vee o1_40 TL084
R3_40 o1_40 n3_40 2015.9815
R4_40 n3_40 n4_40 10097.2579
C3_40 n4_40 0 2.972233e-09
C4_40 out_40 n3_40 1.008163e-08
RA2_40 iv2_40 0 10087.9348
RB2_40 out_40 iv2_40 9966.4417
XU2_40 n4_40 iv2_40 vcc vee out_40 TL084
R1_41 in n1_41 3898.6000
R2_41 n1_41 n2_41 24099.6497
C1_41 n2_41 0 2.108731e-09
C2_41 o1_41 n1_41 3.601076e-09
RA1_41 iv1_41 0 9938.5555
RB1_41 o1_41 iv1_41 10017.3651
XU1_41 n2_41 iv1_41 vcc vee o1_41 TL084
R3_41 o1_41 n3_41 2004.6258
R4_41 n3_41 n4_41 10049.8371
C3_41 n4_41 0 3.456450e-09
C4_41 out_41 n3_41 1.006925e-08
RA2_41 iv2_41 0 9967.1861
RB2_41 out_41 iv2_41 10055.4994
XU2_41 n4_41 iv2_41 vcc vee out_41 TL084
R1_42 in n1_42 3926.6338
R2_42 n1_42 n2_42 24115.0176
C1_42 n2_42 0 2.279542e-09
C2_42 o1_42 n1_42 3.428597e-09
RA1_42 iv1_42 0 10049.6716
RB1_42 o1_42 iv1_42 9935.0325
XU1_42 n2_42 iv1_42 vcc vee o1_42 TL084
R3_42 o1_42 n3_42 1989.6875
R4_42 n3_42 n4_42 10028.7055
C3_42 n4_42 0 3.064131e-09
C4_42 out_42 n3_42 1.097800e-08
RA2_42 iv2_42 0 10041.5587
RB2_42 out_42 iv2_42 10082.4443
XU2_42 n4_42 iv2_42 vcc vee out_42 TL084
R1_43 in n1_43 3899.4913
R2_43 n1_43 n2_43 23870.9373
C1_43 n2_43 0 2.197004e-09
C2_43 o1_43 n1_43 3.506746e-09
RA1_43 iv1_43 0 9937.5601
RB1_43 o1_43 iv1_43 10056.3397
XU1_43 n2_43 iv1_43 vcc vee o1_43 TL084
R3_43 o1_43 n3_43 1990.9087
R4_43 n3_43 n4_43 10075.7560
C3_43 n4_43 0 3.107060e-09
C4_43 out_43 n3_43 9.632563e-09
RA2_43 iv2_43 0 9919.1180
RB2_43 out_43 iv2_43 9906.4849
XU2_43 n4_43 iv2_43 vcc vee out_43 TL084
R1_44 in n1_44 3889.1028
R2_44 n1_44 n2_44 23974.2859
C1_44 n2_44 0 2.006652e-09
C2_44 o1_44 n1_44 3.025621e-09
RA1_44 iv1_44 0 10074.9256
RB1_44 o1_44 iv1_44 10019.7815
XU1_44 n2_44 iv1_44 vcc vee o1_44 TL084
R3_44 o1_44 n3_44 1995.8958
R4_44 n3_44 n4_44 9914.9360
C3_44 n4_44 0 3.326228e-09
C4_44 out_44 n3_44 1.016741e-08
RA2_44 iv2_44 0 9957.4511
RB2_44 out_44 iv2_44 10066.1124
XU2_44 n4_44 iv2_44 vcc vee out_44 TL084
R1_45 in n1_45 3898.2265
R2_45 n1_45 n2_45 23872.2595
C1_45 n2_45 0 2.351076e-09
C2_45 o1_45 n1_45 3.466577e-09
RA1_45 iv1_45 0 10013.5898
RB1_45 o1_45 iv1_45 10064.9634
XU1_45 n2_45 iv1_45 vcc vee o1_45 TL084
R3_45 o1_45 n3_45 1989.3298
R4_45 n3_45 n4_45 9993.0599
C3_45 n4_45 0 3.207316e-09
C4_45 out_45 n3_45 9.670028e-09
RA2_45 iv2_45 0 10013.4732
RB2_45 out_45 iv2_45 9905.9158
XU2_45 n4_45 iv2_45 vcc vee out_45 TL084
R1_46 in n1_46 3874.6993
R2_46 n1_46 n2_46 24077.6967
C1_46 n2_46 0 2.051818e-09
C2_46 o1_46 n1_46 3.527865e-09
RA1_46 iv1_46 0 9945.7179
RB1_46 o1_46 iv1_46 10005.5808
XU1_46 n2_46 iv1_46 vcc vee o1_46 TL084
R3_46 o1_46 n3_46 1991.6475
R4_46 n3_46 n4_46 9993.0394
C3_46 n4_46 0 3.049985e-09
C4_46 out_46 n3_46 9.276860e-09
RA2_46 iv2_46 0 9992.9591
RB2_46 out_46 iv2_46 10024.7371
XU2_46 n4_46 iv2_46 vcc vee out_46 TL084
R1_47 in n1_47 3908.2841
R2_47 n1_47 n2_47 24115.5636
C1_47 n2_47 0 2.315700e-09
C2_47 o1_47 n1_47 3.352272e-09
RA1_47 iv1_47 0 9975.8751
RB1_47 o1_47 iv1_47 10096.6167
XU1_47 n2_47 iv1_47 vcc vee o1_47 TL084
R3_47 o1_47 n3_47 2002.6447
R4_47 n3_47 n4_47 9959.4933
C3_47 n4_47 0 3.355595e-09
C4_47 out_47 n3_47 1.040022e-08
RA2_47 iv2_47 0 9944.4432
RB2_47 out_47 iv2_47 10086.0455
XU2_47 n4_47 iv2_47 vcc vee out_47 TL084
R1_48 in n1_48 3930.1227
R2_48 n1_48 n2_48 24037.1551
C1_48 n2_48 0 2.276238e-09
C2_48 o1_48 n1_48 3.157203e-09
RA1_48 iv1_48 0 10013.8331
RB1_48 o1_48 iv1_48 9965.1443
XU1_48 n2_48 iv1_48 vcc vee o1_48 TL084
R3_48 o1_48 n3_48 1994.4232
R4_48 n3_48 n4_48 9971.9523
C3_48 n4_48 0 3.127029e-09
C4_48 out_48 n3_48 9.404531e-09
RA2_48 iv2_48 0 10002.1735
RB2_48 out_48 iv2_48 9925.3213
XU2_48 n4_48 iv2_48 vcc vee out_48 TL084
R1_49 in n1_49 3872.6348
R2_49 n1_49 n2_49 24146.7105
C1_49 n2_49 0 2.236805e-09
C2_49 o1_49 n1_49 3.478854e-09
RA1_49 iv1_49 0 9952.1973
RB1_49 o1_49 iv1_49 10065.3806
XU1_49 n2_49 iv1_49 vcc vee o1_49 TL084
R3_49 o1_49 n3_49 2007.9043
R4_49 n3_49 n4_49 10069.4277
C3_49 n4_49 0 3.575103e-09
C4_49 out_49 n3_49 1.050385e-08
RA2_49 iv2_49 0 9941.4824
RB2_49 out_49 iv2_49 9905.2211
XU2_49 n4_49 iv2_49 vcc vee out_49 TL084
R1_50 in n1_50 3862.0982
R2_50 n1_50 n2_50 23831.4852
C1_50 n2_50 0 2.082840e-09
C2_50 o1_50 n1_50 3.489242e-09
RA1_50 iv1_50 0 9915.5330
RB1_50 o1_50 iv1_50 10023.2951
XU1_50 n2_50 iv1_50 vcc vee o1_50 TL084
R3_50 o1_50 n3_50 2015.3074
R4_50 n3_50 n4_50 9930.6515
C3_50 n4_50 0 3.406704e-09
C4_50 out_50 n3_50 9.455677e-09
RA2_50 iv2_50 0 10008.7041
RB2_50 out_50 iv2_50 9903.7874
XU2_50 n4_50 iv2_50 vcc vee out_50 TL084
R1_51 in n1_51 3869.8077
R2_51 n1_51 n2_51 24087.2599
C1_51 n2_51 0 2.104116e-09
C2_51 o1_51 n1_51 3.353512e-09
RA1_51 iv1_51 0 10099.0524
RB1_51 o1_51 iv1_51 9973.9070
XU1_51 n2_51 iv1_51 vcc vee o1_51 TL084
R3_51 o1_51 n3_51 2002.3285
R4_51 n3_51 n4_51 9941.7492
C3_51 n4_51 0 3.281090e-09
C4_51 out_51 n3_51 1.016100e-08
RA2_51 iv2_51 0 10071.9603
RB2_51 out_51 iv2_51 10042.3351
XU2_51 n4_51 iv2_51 vcc vee out_51 TL084
R1_52 in n1_52 3881.7013
R2_52 n1_52 n2_52 23763.8708
C1_52 n2_52 0 2.382327e-09
C2_52 o1_52 n1_52 3.382068e-09
RA1_52 iv1_52 0 9928.0083
RB1_52 o1_52 iv1_52 9972.9501
XU1_52 n2_52 iv1_52 vcc vee o1_52 TL084
R3_52 o1_52 n3_52 1990.2812
R4_52 n3_52 n4_52 9966.8417
C3_52 n4_52 0 3.067922e-09
C4_52 out_52 n3_52 9.565105e-09
RA2_52 iv2_52 0 9920.7933
RB2_52 out_52 iv2_52 9901.7775
XU2_52 n4_52 iv2_52 vcc vee out_52 TL084
R1_53 in n1_53 3929.8565
R2_53 n1_53 n2_53 23780.3811
C1_53 n2_53 0 2.057277e-09
C2_53 o1_53 n1_53 3.532114e-09
RA1_53 iv1_53 0 9947.6928
RB1_53 o1_53 iv1_53 10061.1476
XU1_53 n2_53 iv1_53 vcc vee o1_53 TL084
R3_53 o1_53 n3_53 2017.3801
R4_53 n3_53 n4_53 9988.4024
C3_53 n4_53 0 3.466752e-09
C4_53 out_53 n3_53 1.022156e-08
RA2_53 iv2_53 0 10077.8682
RB2_53 out_53 iv2_53 10022.7110
XU2_53 n4_53 iv2_53 vcc vee out_53 TL084
R1_54 in n1_54 3869.6511
R2_54 n1_54 n2_54 23957.5161
C1_54 n2_54 0 2.133802e-09
C2_54 o1_54 n1_54 3.280710e-09
RA1_54 iv1_54 0 9989.8589
RB1_54 o1_54 iv1_54 9981.7313
XU1_54 n2_54 iv1_54 vcc vee o1_54 TL084
R3_54 o1_54 n3_54 2017.0672
R4_54 n3_54 n4_54 10071.4295
C3_54 n4_54 0 3.286515e-09
C4_54 out_54 n3_54 1.085772e-08
RA2_54 iv2_54 0 10018.9907
RB2_54 out_54 iv2_54 10052.9248
XU2_54 n4_54 iv2_54 vcc vee out_54 TL084
R1_55 in n1_55 3862.5289
R2_55 n1_55 n2_55 24131.8940
C1_55 n2_55 0 2.202794e-09
C2_55 o1_55 n1_55 3.451098e-09
RA1_55 iv1_55 0 9971.6469
RB1_55 o1_55 iv1_55 9954.8462
XU1_55 n2_55 iv1_55 vcc vee o1_55 TL084
R3_55 o1_55 n3_55 1997.3098
R4_55 n3_55 n4_55 9959.6150
C3_55 n4_55 0 3.033741e-09
C4_55 out_55 n3_55 1.044882e-08
RA2_55 iv2_55 0 9957.3786
RB2_55 out_55 iv2_55 10036.6961
XU2_55 n4_55 iv2_55 vcc vee out_55 TL084
R1_56 in n1_56 3861.5820
R2_56 n1_56 n2_56 23856.6925
C1_56 n2_56 0 2.286439e-09
C2_56 o1_56 n1_56 3.092322e-09
RA1_56 iv1_56 0 9973.3172
RB1_56 o1_56 iv1_56 10000.0817
XU1_56 n2_56 iv1_56 vcc vee o1_56 TL084
R3_56 o1_56 n3_56 2016.2705
R4_56 n3_56 n4_56 9907.6648
C3_56 n4_56 0 3.394188e-09
C4_56 out_56 n3_56 9.857727e-09
RA2_56 iv2_56 0 10020.3871
RB2_56 out_56 iv2_56 9907.3841
XU2_56 n4_56 iv2_56 vcc vee out_56 TL084
R1_57 in n1_57 3901.8812
R2_57 n1_57 n2_57 23907.1138
C1_57 n2_57 0 2.138007e-09
C2_57 o1_57 n1_57 3.155563e-09
RA1_57 iv1_57 0 9907.0237
RB1_57 o1_57 iv1_57 10019.7122
XU1_57 n2_57 iv1_57 vcc vee o1_57 TL084
R3_57 o1_57 n3_57 2001.4725
R4_57 n3_57 n4_57 9994.0525
C3_57 n4_57 0 3.402931e-09
C4_57 out_57 n3_57 9.885735e-09
RA2_57 iv2_57 0 9988.6352
RB2_57 out_57 iv2_57 10074.7066
XU2_57 n4_57 iv2_57 vcc vee out_57 TL084
R1_58 in n1_58 3898.9230
R2_58 n1_58 n2_58 23851.6790
C1_58 n2_58 0 2.278370e-09
C2_58 o1_58 n1_58 3.565707e-09
RA1_58 iv1_58 0 9924.8366
RB1_58 o1_58 iv1_58 10034.2210
XU1_58 n2_58 iv1_58 vcc vee o1_58 TL084
R3_58 o1_58 n3_58 1980.7992
R4_58 n3_58 n4_58 10038.8437
C3_58 n4_58 0 3.089576e-09
C4_58 out_58 n3_58 9.428103e-09
RA2_58 iv2_58 0 9922.1015
RB2_58 out_58 iv2_58 10002.5848
XU2_58 n4_58 iv2_58 vcc vee out_58 TL084
R1_59 in n1_59 3906.4717
R2_59 n1_59 n2_59 24082.5785
C1_59 n2_59 0 2.210608e-09
C2_59 o1_59 n1_59 3.035148e-09
RA1_59 iv1_59 0 10043.2337
RB1_59 o1_59 iv1_59 10030.3302
XU1_59 n2_59 iv1_59 vcc vee o1_59 TL084
R3_59 o1_59 n3_59 2007.7789
R4_59 n3_59 n4_59 10088.4960
C3_59 n4_59 0 3.394224e-09
C4_59 out_59 n3_59 9.725064e-09
RA2_59 iv2_59 0 10040.2035
RB2_59 out_59 iv2_59 10036.8789
XU2_59 n4_59 iv2_59 vcc vee out_59 TL084
R1_60 in n1_60 3915.6902
R2_60 n1_60 n2_60 23841.9115
C1_60 n2_60 0 2.385648e-09
C2_60 o1_60 n1_60 3.580738e-09
RA1_60 iv1_60 0 9976.1484
RB1_60 o1_60 iv1_60 10007.2897
XU1_60 n2_60 iv1_60 vcc vee o1_60 TL084
R3_60 o1_60 n3_60 2001.6324
R4_60 n3_60 n4_60 9943.5875
C3_60 n4_60 0 3.371699e-09
C4_60 out_60 n3_60 9.802303e-09
RA2_60 iv2_60 0 10033.3003
RB2_60 out_60 iv2_60 10028.4365
XU2_60 n4_60 iv2_60 vcc vee out_60 TL084
R1_61 in n1_61 3898.8089
R2_61 n1_61 n2_61 23863.3673
C1_61 n2_61 0 2.046387e-09
C2_61 o1_61 n1_61 3.383809e-09
RA1_61 iv1_61 0 9992.3468
RB1_61 o1_61 iv1_61 10022.8858
XU1_61 n2_61 iv1_61 vcc vee o1_61 TL084
R3_61 o1_61 n3_61 2002.3629
R4_61 n3_61 n4_61 9967.7157
C3_61 n4_61 0 3.561118e-09
C4_61 out_61 n3_61 9.902626e-09
RA2_61 iv2_61 0 9980.7212
RB2_61 out_61 iv2_61 9958.9591
XU2_61 n4_61 iv2_61 vcc vee out_61 TL084
R1_62 in n1_62 3919.7351
R2_62 n1_62 n2_62 24167.6147
C1_62 n2_62 0 2.406336e-09
C2_62 o1_62 n1_62 3.324973e-09
RA1_62 iv1_62 0 9925.0961
RB1_62 o1_62 iv1_62 9902.3385
XU1_62 n2_62 iv1_62 vcc vee o1_62 TL084
R3_62 o1_62 n3_62 2017.9294
R4_62 n3_62 n4_62 9981.3141
C3_62 n4_62 0 2.976800e-09
C4_62 out_62 n3_62 9.616322e-09
RA2_62 iv2_62 0 10024.0923
RB2_62 out_62 iv2_62 9917.5048
XU2_62 n4_62 iv2_62 vcc vee out_62 TL084
R1_63 in n1_63 3915.7109
R2_63 n1_63 n2_63 23946.3459
C1_63 n2_63 0 2.333100e-09
C2_63 o1_63 n1_63 3.349276e-09
RA1_63 iv1_63 0 9945.0982
RB1_63 o1_63 iv1_63 9905.8139
XU1_63 n2_63 iv1_63 vcc vee o1_63 TL084
R3_63 o1_63 n3_63 2009.4350
R4_63 n3_63 n4_63 9951.2037
C3_63 n4_63 0 3.475811e-09
C4_63 out_63 n3_63 1.063157e-08
RA2_63 iv2_63 0 9928.4316
RB2_63 out_63 iv2_63 10033.3597
XU2_63 n4_63 iv2_63 vcc vee out_63 TL084
R1_64 in n1_64 3885.4008
R2_64 n1_64 n2_64 24046.4840
C1_64 n2_64 0 2.182791e-09
C2_64 o1_64 n1_64 3.169651e-09
RA1_64 iv1_64 0 10029.0092
RB1_64 o1_64 iv1_64 10063.2311
XU1_64 n2_64 iv1_64 vcc vee o1_64 TL084
R3_64 o1_64 n3_64 2013.7034
R4_64 n3_64 n4_64 9919.4151
C3_64 n4_64 0 3.388585e-09
C4_64 out_64 n3_64 1.029372e-08
RA2_64 iv2_64 0 10012.3119
RB2_64 out_64 iv2_64 10089.0065
XU2_64 n4_64 iv2_64 vcc vee out_64 TL084
R1_65 in n1_65 3898.5581
R2_65 n1_65 n2_65 23935.1054
C1_65 n2_65 0 2.056489e-09
C2_65 o1_65 n1_65 3.523623e-09
RA1_65 iv1_65 0 9926.3253
RB1_65 o1_65 iv1_65 10008.2538
XU1_65 n2_65 iv1_65 vcc vee o1_65 TL084
R3_65 o1_65 n3_65 1983.6018
R4_65 n3_65 n4_65 9992.0428
C3_65 n4_65 0 3.039009e-09
C4_65 out_65 n3_65 9.526252e-09
RA2_65 iv2_65 0 9972.5113
RB2_65 out_65 iv2_65 9912.8698
XU2_65 n4_65 iv2_65 vcc vee out_65 TL084
R1_66 in n1_66 3880.0972
R2_66 n1_66 n2_66 24048.0677
C1_66 n2_66 0 2.291861e-09
C2_66 o1_66 n1_66 3.413605e-09
RA1_66 iv1_66 0 9952.7149
RB1_66 o1_66 iv1_66 10098.5336
XU1_66 n2_66 iv1_66 vcc vee o1_66 TL084
R3_66 o1_66 n3_66 1996.3515
R4_66 n3_66 n4_66 10055.0533
C3_66 n4_66 0 3.114560e-09
C4_66 out_66 n3_66 1.095042e-08
RA2_66 iv2_66 0 9973.0119
RB2_66 out_66 iv2_66 9900.0055
XU2_66 n4_66 iv2_66 vcc vee out_66 TL084
R1_67 in n1_67 3909.3215
R2_67 n1_67 n2_67 24157.2757
C1_67 n2_67 0 2.390355e-09
C2_67 o1_67 n1_67 3.044168e-09
RA1_67 iv1_67 0 10064.5959
RB1_67 o1_67 iv1_67 9985.1244
XU1_67 n2_67 iv1_67 vcc vee o1_67 TL084
R3_67 o1_67 n3_67 1982.6306
R4_67 n3_67 n4_67 10005.9759
C3_67 n4_67 0 3.424809e-09
C4_67 out_67 n3_67 9.574177e-09
RA2_67 iv2_67 0 10017.7015
RB2_67 out_67 iv2_67 9959.4338
XU2_67 n4_67 iv2_67 vcc vee out_67 TL084
R1_68 in n1_68 3884.2320
R2_68 n1_68 n2_68 24183.7691
C1_68 n2_68 0 2.179663e-09
C2_68 o1_68 n1_68 3.134493e-09
RA1_68 iv1_68 0 10075.3576
RB1_68 o1_68 iv1_68 9968.2508
XU1_68 n2_68 iv1_68 vcc vee o1_68 TL084
R3_68 o1_68 n3_68 2011.1125
R4_68 n3_68 n4_68 10024.3691
C3_68 n4_68 0 3.412592e-09
C4_68 out_68 n3_68 9.823529e-09
RA2_68 iv2_68 0 10069.8270
RB2_68 out_68 iv2_68 9910.6262
XU2_68 n4_68 iv2_68 vcc vee out_68 TL084
R1_69 in n1_69 3931.7674
R2_69 n1_69 n2_69 23844.9006
C1_69 n2_69 0 2.312418e-09
C2_69 o1_69 n1_69 3.225053e-09
RA1_69 iv1_69 0 9932.8623
RB1_69 o1_69 iv1_69 9911.9547
XU1_69 n2_69 iv1_69 vcc vee o1_69 TL084
R3_69 o1_69 n3_69 2003.3369
R4_69 n3_69 n4_69 10096.6519
C3_69 n4_69 0 3.540560e-09
C4_69 out_69 n3_69 9.918007e-09
RA2_69 iv2_69 0 9960.2702
RB2_69 out_69 iv2_69 9915.1112
XU2_69 n4_69 iv2_69 vcc vee out_69 TL084
R1_70 in n1_70 3871.6132
R2_70 n1_70 n2_70 24122.5974
C1_70 n2_70 0 2.039417e-09
C2_70 o1_70 n1_70 3.535459e-09
RA1_70 iv1_70 0 9965.2732
RB1_70 o1_70 iv1_70 10027.9331
XU1_70 n2_70 iv1_70 vcc vee o1_70 TL084
R3_70 o1_70 n3_70 1989.5259
R4_70 n3_70 n4_70 10042.2558
C3_70 n4_70 0 3.025956e-09
C4_70 out_70 n3_70 9.202289e-09
RA2_70 iv2_70 0 9929.1311
RB2_70 out_70 iv2_70 9979.7938
XU2_70 n4_70 iv2_70 vcc vee out_70 TL084
R1_71 in n1_71 3897.4609
R2_71 n1_71 n2_71 23901.6903
C1_71 n2_71 0 2.375147e-09
C2_71 o1_71 n1_71 3.305904e-09
RA1_71 iv1_71 0 10082.9983
RB1_71 o1_71 iv1_71 10098.2224
XU1_71 n2_71 iv1_71 vcc vee o1_71 TL084
R3_71 o1_71 n3_71 2001.3027
R4_71 n3_71 n4_71 9983.4646
C3_71 n4_71 0 3.156872e-09
C4_71 out_71 n3_71 9.190602e-09
RA2_71 iv2_71 0 9985.4872
RB2_71 out_71 iv2_71 9973.3849
XU2_71 n4_71 iv2_71 vcc vee out_71 TL084
R1_72 in n1_72 3894.8236
R2_72 n1_72 n2_72 23986.6455
C1_72 n2_72 0 2.353532e-09
C2_72 o1_72 n1_72 3.604756e-09
RA1_72 iv1_72 0 9971.5618
RB1_72 o1_72 iv1_72 10096.2899
XU1_72 n2_72 iv1_72 vcc vee o1_72 TL084
R3_72 o1_72 n3_72 1995.5589
R4_72 n3_72 n4_72 10024.6482
C3_72 n4_72 0 3.517366e-09
C4_72 out_72 n3_72 1.036573e-08
RA2_72 iv2_72 0 10084.1804
RB2_72 out_72 iv2_72 9920.7375
XU2_72 n4_72 iv2_72 vcc vee out_72 TL084
R1_73 in n1_73 3936.5720
R2_73 n1_73 n2_73 23903.8243
C1_73 n2_73 0 2.109472e-09
C2_73 o1_73 n1_73 2.987521e-09
RA1_73 iv1_73 0 10028.7782
RB1_73 o1_73 iv1_73 9915.7523
XU1_73 n2_73 iv1_73 vcc vee o1_73 TL084
R3_73 o1_73 n3_73 1996.5895
R4_73 n3_73 n4_73 9921.0771
C3_73 n4_73 0 3.047232e-09
C4_73 out_73 n3_73 9.506654e-09
RA2_73 iv2_73 0 10093.8201
RB2_73 out_73 iv2_73 9991.3914
XU2_73 n4_73 iv2_73 vcc vee out_73 TL084
R1_74 in n1_74 3897.8063
R2_74 n1_74 n2_74 24107.2992
C1_74 n2_74 0 2.218513e-09
C2_74 o1_74 n1_74 3.262414e-09
RA1_74 iv1_74 0 9955.4377
RB1_74 o1_74 iv1_74 9977.4641
XU1_74 n2_74 iv1_74 vcc vee o1_74 TL084
R3_74 o1_74 n3_74 1983.5611
R4_74 n3_74 n4_74 10043.4904
C3_74 n4_74 0 3.098080e-09
C4_74 out_74 n3_74 9.794135e-09
RA2_74 iv2_74 0 10007.7609
RB2_74 out_74 iv2_74 10038.2853
XU2_74 n4_74 iv2_74 vcc vee out_74 TL084
R1_75 in n1_75 3938.3270
R2_75 n1_75 n2_75 24069.8819
C1_75 n2_75 0 2.089350e-09
C2_75 o1_75 n1_75 3.351782e-09
RA1_75 iv1_75 0 9938.4650
RB1_75 o1_75 iv1_75 9936.2183
XU1_75 n2_75 iv1_75 vcc vee o1_75 TL084
R3_75 o1_75 n3_75 2013.0270
R4_75 n3_75 n4_75 9995.7496
C3_75 n4_75 0 3.579968e-09
C4_75 out_75 n3_75 1.012347e-08
RA2_75 iv2_75 0 9927.7317
RB2_75 out_75 iv2_75 9928.1865
XU2_75 n4_75 iv2_75 vcc vee out_75 TL084
R1_76 in n1_76 3934.5788
R2_76 n1_76 n2_76 23888.4386
C1_76 n2_76 0 2.098847e-09
C2_76 o1_76 n1_76 3.074608e-09
RA1_76 iv1_76 0 10009.6182
RB1_76 o1_76 iv1_76 10042.8038
XU1_76 n2_76 iv1_76 vcc vee o1_76 TL084
R3_76 o1_76 n3_76 2008.3769
R4_76 n3_76 n4_76 10041.6292
C3_76 n4_76 0 3.052726e-09
C4_76 out_76 n3_76 1.040434e-08
RA2_76 iv2_76 0 9990.4328
RB2_76 out_76 iv2_76 10005.4602
XU2_76 n4_76 iv2_76 vcc vee out_76 TL084
R1_77 in n1_77 3916.1552
R2_77 n1_77 n2_77 23963.6689
C1_77 n2_77 0 2.156899e-09
C2_77 o1_77 n1_77 3.408034e-09
RA1_77 iv1_77 0 9996.9330
RB1_77 o1_77 iv1_77 10090.5341
XU1_77 n2_77 iv1_77 vcc vee o1_77 TL084
R3_77 o1_77 n3_77 1997.1572
R4_77 n3_77 n4_77 10068.5871
C3_77 n4_77 0 3.236724e-09
C4_77 out_77 n3_77 9.011009e-09
RA2_77 iv2_77 0 10056.3236
RB2_77 out_77 iv2_77 9923.0139
XU2_77 n4_77 iv2_77 vcc vee out_77 TL084
R1_78 in n1_78 3865.9758
R2_78 n1_78 n2_78 23860.4264
C1_78 n2_78 0 2.202515e-09
C2_78 o1_78 n1_78 3.200924e-09
RA1_78 iv1_78 0 9955.0374
RB1_78 o1_78 iv1_78 9956.7947
XU1_78 n2_78 iv1_78 vcc vee o1_78 TL084
R3_78 o1_78 n3_78 2006.3006
R4_78 n3_78 n4_78 9996.3626
C3_78 n4_78 0 2.976735e-09
C4_78 out_78 n3_78 1.003512e-08
RA2_78 iv2_78 0 9999.6014
RB2_78 out_78 iv2_78 9978.3876
XU2_78 n4_78 iv2_78 vcc vee out_78 TL084
R1_79 in n1_79 3914.1750
R2_79 n1_79 n2_79 23864.0130
C1_79 n2_79 0 2.410722e-09
C2_79 o1_79 n1_79 3.383104e-09
RA1_79 iv1_79 0 9914.6053
RB1_79 o1_79 iv1_79 9988.0917
XU1_79 n2_79 iv1_79 vcc vee o1_79 TL084
R3_79 o1_79 n3_79 1991.7749
R4_79 n3_79 n4_79 10035.2747
C3_79 n4_79 0 3.103486e-09
C4_79 out_79 n3_79 1.045081e-08
RA2_79 iv2_79 0 10031.8474
RB2_79 out_79 iv2_79 9994.4135
XU2_79 n4_79 iv2_79 vcc vee out_79 TL084
R1_80 in n1_80 3884.5138
R2_80 n1_80 n2_80 24029.3432
C1_80 n2_80 0 2.092879e-09
C2_80 o1_80 n1_80 3.046856e-09
RA1_80 iv1_80 0 9931.7071
RB1_80 o1_80 iv1_80 10036.0738
XU1_80 n2_80 iv1_80 vcc vee o1_80 TL084
R3_80 o1_80 n3_80 1982.1957
R4_80 n3_80 n4_80 10084.1734
C3_80 n4_80 0 3.086876e-09
C4_80 out_80 n3_80 9.926510e-09
RA2_80 iv2_80 0 10094.6567
RB2_80 out_80 iv2_80 9971.6993
XU2_80 n4_80 iv2_80 vcc vee out_80 TL084
R1_81 in n1_81 3907.0594
R2_81 n1_81 n2_81 24153.8951
C1_81 n2_81 0 2.394704e-09
C2_81 o1_81 n1_81 3.409050e-09
RA1_81 iv1_81 0 9961.8000
RB1_81 o1_81 iv1_81 10026.6277
XU1_81 n2_81 iv1_81 vcc vee o1_81 TL084
R3_81 o1_81 n3_81 1981.0307
R4_81 n3_81 n4_81 9960.7905
C3_81 n4_81 0 3.143898e-09
C4_81 out_81 n3_81 9.485671e-09
RA2_81 iv2_81 0 9925.0714
RB2_81 out_81 iv2_81 9996.8588
XU2_81 n4_81 iv2_81 vcc vee out_81 TL084
R1_82 in n1_82 3873.8396
R2_82 n1_82 n2_82 23991.2911
C1_82 n2_82 0 2.021825e-09
C2_82 o1_82 n1_82 3.030335e-09
RA1_82 iv1_82 0 10095.6516
RB1_82 o1_82 iv1_82 9989.1083
XU1_82 n2_82 iv1_82 vcc vee o1_82 TL084
R3_82 o1_82 n3_82 1987.7990
R4_82 n3_82 n4_82 10061.2097
C3_82 n4_82 0 3.624336e-09
C4_82 out_82 n3_82 9.146583e-09
RA2_82 iv2_82 0 9908.8980
RB2_82 out_82 iv2_82 9964.7878
XU2_82 n4_82 iv2_82 vcc vee out_82 TL084
R1_83 in n1_83 3902.9036
R2_83 n1_83 n2_83 24066.5497
C1_83 n2_83 0 2.271754e-09
C2_83 o1_83 n1_83 3.487897e-09
RA1_83 iv1_83 0 9936.8418
RB1_83 o1_83 iv1_83 9979.3447
XU1_83 n2_83 iv1_83 vcc vee o1_83 TL084
R3_83 o1_83 n3_83 1996.4118
R4_83 n3_83 n4_83 9906.1002
C3_83 n4_83 0 3.260724e-09
C4_83 out_83 n3_83 1.019075e-08
RA2_83 iv2_83 0 10090.8801
RB2_83 out_83 iv2_83 9958.3584
XU2_83 n4_83 iv2_83 vcc vee out_83 TL084
R1_84 in n1_84 3901.9738
R2_84 n1_84 n2_84 23903.3429
C1_84 n2_84 0 2.298349e-09
C2_84 o1_84 n1_84 3.253874e-09
RA1_84 iv1_84 0 10027.5745
RB1_84 o1_84 iv1_84 9967.6907
XU1_84 n2_84 iv1_84 vcc vee o1_84 TL084
R3_84 o1_84 n3_84 2001.0555
R4_84 n3_84 n4_84 9937.2677
C3_84 n4_84 0 3.433970e-09
C4_84 out_84 n3_84 9.418780e-09
RA2_84 iv2_84 0 10060.1741
RB2_84 out_84 iv2_84 10086.4982
XU2_84 n4_84 iv2_84 vcc vee out_84 TL084
R1_85 in n1_85 3904.6476
R2_85 n1_85 n2_85 24169.8563
C1_85 n2_85 0 2.257648e-09
C2_85 o1_85 n1_85 3.261917e-09
RA1_85 iv1_85 0 9913.2003
RB1_85 o1_85 iv1_85 10035.8198
XU1_85 n2_85 iv1_85 vcc vee o1_85 TL084
R3_85 o1_85 n3_85 2011.0869
R4_85 n3_85 n4_85 9971.0957
C3_85 n4_85 0 3.038024e-09
C4_85 out_85 n3_85 1.039677e-08
RA2_85 iv2_85 0 9960.2512
RB2_85 out_85 iv2_85 9916.2831
XU2_85 n4_85 iv2_85 vcc vee out_85 TL084
R1_86 in n1_86 3933.2704
R2_86 n1_86 n2_86 23924.5099
C1_86 n2_86 0 2.376195e-09
C2_86 o1_86 n1_86 3.130054e-09
RA1_86 iv1_86 0 9990.3646
RB1_86 o1_86 iv1_86 10015.5792
XU1_86 n2_86 iv1_86 vcc vee o1_86 TL084
R3_86 o1_86 n3_86 1999.4298
R4_86 n3_86 n4_86 9950.5900
C3_86 n4_86 0 3.482451e-09
C4_86 out_86 n3_86 9.576524e-09
RA2_86 iv2_86 0 10059.1981
RB2_86 out_86 iv2_86 9902.3318
XU2_86 n4_86 iv2_86 vcc vee out_86 TL084
R1_87 in n1_87 3934.0822
R2_87 n1_87 n2_87 24236.6910
C1_87 n2_87 0 2.018996e-09
C2_87 o1_87 n1_87 3.279905e-09
RA1_87 iv1_87 0 10063.3724
RB1_87 o1_87 iv1_87 10010.5382
XU1_87 n2_87 iv1_87 vcc vee o1_87 TL084
R3_87 o1_87 n3_87 1996.0166
R4_87 n3_87 n4_87 9935.8630
C3_87 n4_87 0 3.156414e-09
C4_87 out_87 n3_87 1.027247e-08
RA2_87 iv2_87 0 10013.8585
RB2_87 out_87 iv2_87 10042.8398
XU2_87 n4_87 iv2_87 vcc vee out_87 TL084
R1_88 in n1_88 3918.7450
R2_88 n1_88 n2_88 24165.2543
C1_88 n2_88 0 2.386216e-09
C2_88 o1_88 n1_88 3.349742e-09
RA1_88 iv1_88 0 10074.4339
RB1_88 o1_88 iv1_88 9960.4157
XU1_88 n2_88 iv1_88 vcc vee o1_88 TL084
R3_88 o1_88 n3_88 2019.5605
R4_88 n3_88 n4_88 10044.6814
C3_88 n4_88 0 3.327030e-09
C4_88 out_88 n3_88 1.078251e-08
RA2_88 iv2_88 0 10018.1028
RB2_88 out_88 iv2_88 10083.7984
XU2_88 n4_88 iv2_88 vcc vee out_88 TL084
R1_89 in n1_89 3927.3054
R2_89 n1_89 n2_89 24014.9183
C1_89 n2_89 0 2.398113e-09
C2_89 o1_89 n1_89 3.042394e-09
RA1_89 iv1_89 0 10088.7651
RB1_89 o1_89 iv1_89 9914.3798
XU1_89 n2_89 iv1_89 vcc vee o1_89 TL084
R3_89 o1_89 n3_89 2000.2678
R4_89 n3_89 n4_89 10071.0969
C3_89 n4_89 0 3.077927e-09
C4_89 out_89 n3_89 9.008555e-09
RA2_89 iv2_89 0 10041.8012
RB2_89 out_89 iv2_89 9971.2292
XU2_89 n4_89 iv2_89 vcc vee out_89 TL084
R1_90 in n1_90 3872.1530
R2_90 n1_90 n2_90 23958.6507
C1_90 n2_90 0 2.382805e-09
C2_90 o1_90 n1_90 3.460499e-09
RA1_90 iv1_90 0 9943.7534
RB1_90 o1_90 iv1_90 9929.4053
XU1_90 n2_90 iv1_90 vcc vee o1_90 TL084
R3_90 o1_90 n3_90 2011.8298
R4_90 n3_90 n4_90 9964.0796
C3_90 n4_90 0 3.562897e-09
C4_90 out_90 n3_90 9.641922e-09
RA2_90 iv2_90 0 9965.9881
RB2_90 out_90 iv2_90 10069.8616
XU2_90 n4_90 iv2_90 vcc vee out_90 TL084
R1_91 in n1_91 3866.2166
R2_91 n1_91 n2_91 23788.8234
C1_91 n2_91 0 2.037980e-09
C2_91 o1_91 n1_91 3.501229e-09
RA1_91 iv1_91 0 10024.6639
RB1_91 o1_91 iv1_91 10079.4962
XU1_91 n2_91 iv1_91 vcc vee o1_91 TL084
R3_91 o1_91 n3_91 1995.0161
R4_91 n3_91 n4_91 10010.2101
C3_91 n4_91 0 3.597133e-09
C4_91 out_91 n3_91 1.056581e-08
RA2_91 iv2_91 0 10000.7351
RB2_91 out_91 iv2_91 9942.9604
XU2_91 n4_91 iv2_91 vcc vee out_91 TL084
R1_92 in n1_92 3914.5127
R2_92 n1_92 n2_92 24096.1421
C1_92 n2_92 0 2.288327e-09
C2_92 o1_92 n1_92 3.072621e-09
RA1_92 iv1_92 0 9991.2155
RB1_92 o1_92 iv1_92 10067.4010
XU1_92 n2_92 iv1_92 vcc vee o1_92 TL084
R3_92 o1_92 n3_92 2016.7291
R4_92 n3_92 n4_92 10093.4034
C3_92 n4_92 0 3.252717e-09
C4_92 out_92 n3_92 9.908496e-09
RA2_92 iv2_92 0 10051.8826
RB2_92 out_92 iv2_92 10012.6745
XU2_92 n4_92 iv2_92 vcc vee out_92 TL084
R1_93 in n1_93 3905.3991
R2_93 n1_93 n2_93 24080.9993
C1_93 n2_93 0 2.049951e-09
C2_93 o1_93 n1_93 3.218906e-09
RA1_93 iv1_93 0 10029.3906
RB1_93 o1_93 iv1_93 10023.0324
XU1_93 n2_93 iv1_93 vcc vee o1_93 TL084
R3_93 o1_93 n3_93 2006.3907
R4_93 n3_93 n4_93 9968.3822
C3_93 n4_93 0 3.049001e-09
C4_93 out_93 n3_93 1.021629e-08
RA2_93 iv2_93 0 10072.1518
RB2_93 out_93 iv2_93 9967.7751
XU2_93 n4_93 iv2_93 vcc vee out_93 TL084
R1_94 in n1_94 3877.7011
R2_94 n1_94 n2_94 24118.9973
C1_94 n2_94 0 2.042811e-09
C2_94 o1_94 n1_94 3.605271e-09
RA1_94 iv1_94 0 10066.0395
RB1_94 o1_94 iv1_94 10080.5084
XU1_94 n2_94 iv1_94 vcc vee o1_94 TL084
R3_94 o1_94 n3_94 1999.9898
R4_94 n3_94 n4_94 9961.0321
C3_94 n4_94 0 3.355394e-09
C4_94 out_94 n3_94 9.372857e-09
RA2_94 iv2_94 0 9901.4255
RB2_94 out_94 iv2_94 9974.1778
XU2_94 n4_94 iv2_94 vcc vee out_94 TL084
R1_95 in n1_95 3923.6173
R2_95 n1_95 n2_95 23862.0632
C1_95 n2_95 0 2.099941e-09
C2_95 o1_95 n1_95 3.424939e-09
RA1_95 iv1_95 0 10016.0611
RB1_95 o1_95 iv1_95 9972.2469
XU1_95 n2_95 iv1_95 vcc vee o1_95 TL084
R3_95 o1_95 n3_95 2009.4770
R4_95 n3_95 n4_95 9937.3825
C3_95 n4_95 0 3.559349e-09
C4_95 out_95 n3_95 9.674551e-09
RA2_95 iv2_95 0 10049.1776
RB2_95 out_95 iv2_95 10032.2478
XU2_95 n4_95 iv2_95 vcc vee out_95 TL084
R1_96 in n1_96 3896.9237
R2_96 n1_96 n2_96 23902.4861
C1_96 n2_96 0 2.195948e-09
C2_96 o1_96 n1_96 3.117102e-09
RA1_96 iv1_96 0 10062.4573
RB1_96 o1_96 iv1_96 10068.8317
XU1_96 n2_96 iv1_96 vcc vee o1_96 TL084
R3_96 o1_96 n3_96 2017.3215
R4_96 n3_96 n4_96 10071.4645
C3_96 n4_96 0 3.586267e-09
C4_96 out_96 n3_96 9.368830e-09
RA2_96 iv2_96 0 9983.3499
RB2_96 out_96 iv2_96 9958.2371
XU2_96 n4_96 iv2_96 vcc vee out_96 TL084
R1_97 in n1_97 3865.2655
R2_97 n1_97 n2_97 23816.7400
C1_97 n2_97 0 2.141354e-09
C2_97 o1_97 n1_97 3.376449e-09
RA1_97 iv1_97 0 10031.3016
RB1_97 o1_97 iv1_97 10028.2123
XU1_97 n2_97 iv1_97 vcc vee o1_97 TL084
R3_97 o1_97 n3_97 2018.0851
R4_97 n3_97 n4_97 10006.5159
C3_97 n4_97 0 3.352842e-09
C4_97 out_97 n3_97 9.312188e-09
RA2_97 iv2_97 0 10022.9647
RB2_97 out_97 iv2_97 9960.1892
XU2_97 n4_97 iv2_97 vcc vee out_97 TL084
R1_98 in n1_98 3904.3145
R2_98 n1_98 n2_98 24038.8092
C1_98 n2_98 0 2.164659e-09
C2_98 o1_98 n1_98 3.501251e-09
RA1_98 iv1_98 0 9909.0818
RB1_98 o1_98 iv1_98 9968.7773
XU1_98 n2_98 iv1_98 vcc vee o1_98 TL084
R3_98 o1_98 n3_98 1984.8932
R4_98 n3_98 n4_98 9989.5939
C3_98 n4_98 0 3.534218e-09
C4_98 out_98 n3_98 9.177926e-09
RA2_98 iv2_98 0 9940.0361
RB2_98 out_98 iv2_98 10020.1267
XU2_98 n4_98 iv2_98 vcc vee out_98 TL084
R1_99 in n1_99 3865.1728
R2_99 n1_99 n2_99 24050.9604
C1_99 n2_99 0 2.039984e-09
C2_99 o1_99 n1_99 3.265889e-09
RA1_99 iv1_99 0 9998.4001
RB1_99 o1_99 iv1_99 9972.4412
XU1_99 n2_99 iv1_99 vcc vee o1_99 TL084
R3_99 o1_99 n3_99 1998.7704
R4_99 n3_99 n4_99 9943.8113
C3_99 n4_99 0 3.158056e-09
C4_99 out_99 n3_99 9.692214e-09
RA2_99 iv2_99 0 10079.6352
RB2_99 out_99 iv2_99 9978.9446
XU2_99 n4_99 iv2_99 vcc vee out_99 TL084
R1_100 in n1_100 3868.5005
R2_100 n1_100 n2_100 23977.9156
C1_100 n2_100 0 1.982335e-09
C2_100 o1_100 n1_100 3.435681e-09
RA1_100 iv1_100 0 10012.9809
RB1_100 o1_100 iv1_100 10072.6072
XU1_100 n2_100 iv1_100 vcc vee o1_100 TL084
R3_100 o1_100 n3_100 1984.5098
R4_100 n3_100 n4_100 10012.9961
C3_100 n4_100 0 2.973767e-09
C4_100 out_100 n3_100 1.021733e-08
RA2_100 iv2_100 0 9918.8625
RB2_100 out_100 iv2_100 10057.7370
XU2_100 n4_100 iv2_100 vcc vee out_100 TL084
R1_101 in n1_101 3894.6070
R2_101 n1_101 n2_101 23966.0697
C1_101 n2_101 0 2.389922e-09
C2_101 o1_101 n1_101 2.987085e-09
RA1_101 iv1_101 0 10074.0206
RB1_101 o1_101 iv1_101 10069.8034
XU1_101 n2_101 iv1_101 vcc vee o1_101 TL084
R3_101 o1_101 n3_101 1996.3216
R4_101 n3_101 n4_101 10099.9016
C3_101 n4_101 0 3.408734e-09
C4_101 out_101 n3_101 1.006680e-08
RA2_101 iv2_101 0 9978.7138
RB2_101 out_101 iv2_101 9987.9373
XU2_101 n4_101 iv2_101 vcc vee out_101 TL084
R1_102 in n1_102 3863.6647
R2_102 n1_102 n2_102 23869.8833
C1_102 n2_102 0 2.225250e-09
C2_102 o1_102 n1_102 3.162915e-09
RA1_102 iv1_102 0 9976.5130
RB1_102 o1_102 iv1_102 10024.5707
XU1_102 n2_102 iv1_102 vcc vee o1_102 TL084
R3_102 o1_102 n3_102 2000.5932
R4_102 n3_102 n4_102 9950.4717
C3_102 n4_102 0 3.130351e-09
C4_102 out_102 n3_102 9.833507e-09
RA2_102 iv2_102 0 9951.5714
RB2_102 out_102 iv2_102 9985.6181
XU2_102 n4_102 iv2_102 vcc vee out_102 TL084
R1_103 in n1_103 3885.6971
R2_103 n1_103 n2_103 24231.8383
C1_103 n2_103 0 2.092812e-09
C2_103 o1_103 n1_103 3.371211e-09
RA1_103 iv1_103 0 10007.1540
RB1_103 o1_103 iv1_103 10055.0809
XU1_103 n2_103 iv1_103 vcc vee o1_103 TL084
R3_103 o1_103 n3_103 2013.2753
R4_103 n3_103 n4_103 9983.1101
C3_103 n4_103 0 3.084584e-09
C4_103 out_103 n3_103 1.066549e-08
RA2_103 iv2_103 0 9950.8698
RB2_103 out_103 iv2_103 9991.6373
XU2_103 n4_103 iv2_103 vcc vee out_103 TL084
R1_104 in n1_104 3868.7289
R2_104 n1_104 n2_104 23918.4941
C1_104 n2_104 0 2.071756e-09
C2_104 o1_104 n1_104 3.000504e-09
RA1_104 iv1_104 0 10094.0463
RB1_104 o1_104 iv1_104 10042.2639
XU1_104 n2_104 iv1_104 vcc vee o1_104 TL084
R3_104 o1_104 n3_104 1999.6237
R4_104 n3_104 n4_104 10077.8707
C3_104 n4_104 0 3.198694e-09
C4_104 out_104 n3_104 1.042974e-08
RA2_104 iv2_104 0 10052.2421
RB2_104 out_104 iv2_104 10007.9188
XU2_104 n4_104 iv2_104 vcc vee out_104 TL084
R1_105 in n1_105 3890.1836
R2_105 n1_105 n2_105 23946.5269
C1_105 n2_105 0 2.073642e-09
C2_105 o1_105 n1_105 3.034964e-09
RA1_105 iv1_105 0 10051.1670
RB1_105 o1_105 iv1_105 9908.3320
XU1_105 n2_105 iv1_105 vcc vee o1_105 TL084
R3_105 o1_105 n3_105 1990.5461
R4_105 n3_105 n4_105 9947.9366
C3_105 n4_105 0 3.104939e-09
C4_105 out_105 n3_105 1.048001e-08
RA2_105 iv2_105 0 9960.5919
RB2_105 out_105 iv2_105 10072.0054
XU2_105 n4_105 iv2_105 vcc vee out_105 TL084
R1_106 in n1_106 3873.9804
R2_106 n1_106 n2_106 23800.1462
C1_106 n2_106 0 2.297633e-09
C2_106 o1_106 n1_106 3.043477e-09
RA1_106 iv1_106 0 9984.9749
RB1_106 o1_106 iv1_106 9976.9818
XU1_106 n2_106 iv1_106 vcc vee o1_106 TL084
R3_106 o1_106 n3_106 1995.0300
R4_106 n3_106 n4_106 9921.9767
C3_106 n4_106 0 3.629306e-09
C4_106 out_106 n3_106 1.040833e-08
RA2_106 iv2_106 0 10044.6521
RB2_106 out_106 iv2_106 10043.2750
XU2_106 n4_106 iv2_106 vcc vee out_106 TL084
R1_107 in n1_107 3911.7803
R2_107 n1_107 n2_107 23807.3839
C1_107 n2_107 0 2.104392e-09
C2_107 o1_107 n1_107 3.472167e-09
RA1_107 iv1_107 0 9924.8104
RB1_107 o1_107 iv1_107 9997.8581
XU1_107 n2_107 iv1_107 vcc vee o1_107 TL084
R3_107 o1_107 n3_107 2012.2417
R4_107 n3_107 n4_107 9968.8602
C3_107 n4_107 0 3.329101e-09
C4_107 out_107 n3_107 9.630958e-09
RA2_107 iv2_107 0 10029.0225
RB2_107 out_107 iv2_107 10092.9294
XU2_107 n4_107 iv2_107 vcc vee out_107 TL084
R1_108 in n1_108 3925.0774
R2_108 n1_108 n2_108 24219.5108
C1_108 n2_108 0 2.373179e-09
C2_108 o1_108 n1_108 3.216421e-09
RA1_108 iv1_108 0 9981.9094
RB1_108 o1_108 iv1_108 10017.8273
XU1_108 n2_108 iv1_108 vcc vee o1_108 TL084
R3_108 o1_108 n3_108 2015.9388
R4_108 n3_108 n4_108 9911.1516
C3_108 n4_108 0 3.409326e-09
C4_108 out_108 n3_108 9.851019e-09
RA2_108 iv2_108 0 10013.1937
RB2_108 out_108 iv2_108 10022.9708
XU2_108 n4_108 iv2_108 vcc vee out_108 TL084
R1_109 in n1_109 3872.7439
R2_109 n1_109 n2_109 24113.2514
C1_109 n2_109 0 2.142828e-09
C2_109 o1_109 n1_109 3.355439e-09
RA1_109 iv1_109 0 10080.8429
RB1_109 o1_109 iv1_109 10003.0261
XU1_109 n2_109 iv1_109 vcc vee o1_109 TL084
R3_109 o1_109 n3_109 1990.7300
R4_109 n3_109 n4_109 10045.2426
C3_109 n4_109 0 3.305593e-09
C4_109 out_109 n3_109 1.034789e-08
RA2_109 iv2_109 0 9918.6256
RB2_109 out_109 iv2_109 9979.5573
XU2_109 n4_109 iv2_109 vcc vee out_109 TL084
R1_110 in n1_110 3876.8507
R2_110 n1_110 n2_110 23881.2680
C1_110 n2_110 0 2.162057e-09
C2_110 o1_110 n1_110 3.201907e-09
RA1_110 iv1_110 0 9946.6202
RB1_110 o1_110 iv1_110 9917.6678
XU1_110 n2_110 iv1_110 vcc vee o1_110 TL084
R3_110 o1_110 n3_110 2011.5831
R4_110 n3_110 n4_110 9988.5031
C3_110 n4_110 0 3.582816e-09
C4_110 out_110 n3_110 9.778940e-09
RA2_110 iv2_110 0 10021.0866
RB2_110 out_110 iv2_110 10007.0229
XU2_110 n4_110 iv2_110 vcc vee out_110 TL084
R1_111 in n1_111 3880.4087
R2_111 n1_111 n2_111 23783.5836
C1_111 n2_111 0 2.407891e-09
C2_111 o1_111 n1_111 3.239115e-09
RA1_111 iv1_111 0 9997.5816
RB1_111 o1_111 iv1_111 10087.9456
XU1_111 n2_111 iv1_111 vcc vee o1_111 TL084
R3_111 o1_111 n3_111 1997.0830
R4_111 n3_111 n4_111 9931.3583
C3_111 n4_111 0 3.309769e-09
C4_111 out_111 n3_111 1.015066e-08
RA2_111 iv2_111 0 9943.8456
RB2_111 out_111 iv2_111 9928.5659
XU2_111 n4_111 iv2_111 vcc vee out_111 TL084
R1_112 in n1_112 3883.3786
R2_112 n1_112 n2_112 23814.8211
C1_112 n2_112 0 2.108494e-09
C2_112 o1_112 n1_112 3.300581e-09
RA1_112 iv1_112 0 10079.7035
RB1_112 o1_112 iv1_112 9941.9957
XU1_112 n2_112 iv1_112 vcc vee o1_112 TL084
R3_112 o1_112 n3_112 1980.9939
R4_112 n3_112 n4_112 9929.1487
C3_112 n4_112 0 3.547973e-09
C4_112 out_112 n3_112 9.389492e-09
RA2_112 iv2_112 0 9988.2525
RB2_112 out_112 iv2_112 10042.2306
XU2_112 n4_112 iv2_112 vcc vee out_112 TL084
R1_113 in n1_113 3876.6915
R2_113 n1_113 n2_113 24017.7343
C1_113 n2_113 0 2.047722e-09
C2_113 o1_113 n1_113 3.088919e-09
RA1_113 iv1_113 0 9977.6243
RB1_113 o1_113 iv1_113 10070.0276
XU1_113 n2_113 iv1_113 vcc vee o1_113 TL084
R3_113 o1_113 n3_113 2013.8369
R4_113 n3_113 n4_113 10048.8508
C3_113 n4_113 0 3.204464e-09
C4_113 out_113 n3_113 9.052862e-09
RA2_113 iv2_113 0 9904.0138
RB2_113 out_113 iv2_113 10062.4502
XU2_113 n4_113 iv2_113 vcc vee out_113 TL084
R1_114 in n1_114 3870.3320
R2_114 n1_114 n2_114 24156.7352
C1_114 n2_114 0 2.348892e-09
C2_114 o1_114 n1_114 3.604076e-09
RA1_114 iv1_114 0 10081.7447
RB1_114 o1_114 iv1_114 9998.9329
XU1_114 n2_114 iv1_114 vcc vee o1_114 TL084
R3_114 o1_114 n3_114 2008.1807
R4_114 n3_114 n4_114 10069.8291
C3_114 n4_114 0 3.614103e-09
C4_114 out_114 n3_114 9.608612e-09
RA2_114 iv2_114 0 9965.3612
RB2_114 out_114 iv2_114 9959.0897
XU2_114 n4_114 iv2_114 vcc vee out_114 TL084
R1_115 in n1_115 3887.4467
R2_115 n1_115 n2_115 24161.2923
C1_115 n2_115 0 2.021861e-09
C2_115 o1_115 n1_115 3.518706e-09
RA1_115 iv1_115 0 10093.5360
RB1_115 o1_115 iv1_115 10004.4225
XU1_115 n2_115 iv1_115 vcc vee o1_115 TL084
R3_115 o1_115 n3_115 2010.0479
R4_115 n3_115 n4_115 10022.5784
C3_115 n4_115 0 3.565947e-09
C4_115 out_115 n3_115 1.097878e-08
RA2_115 iv2_115 0 9925.3452
RB2_115 out_115 iv2_115 9972.7733
XU2_115 n4_115 iv2_115 vcc vee out_115 TL084
R1_116 in n1_116 3883.9611
R2_116 n1_116 n2_116 23915.1926
C1_116 n2_116 0 2.040534e-09
C2_116 o1_116 n1_116 3.614212e-09
RA1_116 iv1_116 0 10041.7325
RB1_116 o1_116 iv1_116 10064.6419
XU1_116 n2_116 iv1_116 vcc vee o1_116 TL084
R3_116 o1_116 n3_116 2007.2368
R4_116 n3_116 n4_116 9975.2560
C3_116 n4_116 0 3.128542e-09
C4_116 out_116 n3_116 9.536325e-09
RA2_116 iv2_116 0 10034.6793
RB2_116 out_116 iv2_116 9987.3994
XU2_116 n4_116 iv2_116 vcc vee out_116 TL084
R1_117 in n1_117 3928.2091
R2_117 n1_117 n2_117 24074.1782
C1_117 n2_117 0 2.280755e-09
C2_117 o1_117 n1_117 3.562932e-09
RA1_117 iv1_117 0 10094.5960
RB1_117 o1_117 iv1_117 9971.7370
XU1_117 n2_117 iv1_117 vcc vee o1_117 TL084
R3_117 o1_117 n3_117 1992.5804
R4_117 n3_117 n4_117 10073.2108
C3_117 n4_117 0 3.430164e-09
C4_117 out_117 n3_117 1.025052e-08
RA2_117 iv2_117 0 10055.4564
RB2_117 out_117 iv2_117 9944.9288
XU2_117 n4_117 iv2_117 vcc vee out_117 TL084
R1_118 in n1_118 3862.0440
R2_118 n1_118 n2_118 23916.2760
C1_118 n2_118 0 2.337695e-09
C2_118 o1_118 n1_118 3.133072e-09
RA1_118 iv1_118 0 10017.9884
RB1_118 o1_118 iv1_118 10093.8815
XU1_118 n2_118 iv1_118 vcc vee o1_118 TL084
R3_118 o1_118 n3_118 1982.0786
R4_118 n3_118 n4_118 9999.8405
C3_118 n4_118 0 3.169731e-09
C4_118 out_118 n3_118 9.960802e-09
RA2_118 iv2_118 0 9926.8748
RB2_118 out_118 iv2_118 9989.3450
XU2_118 n4_118 iv2_118 vcc vee out_118 TL084
R1_119 in n1_119 3863.2204
R2_119 n1_119 n2_119 23766.7477
C1_119 n2_119 0 2.025422e-09
C2_119 o1_119 n1_119 3.597961e-09
RA1_119 iv1_119 0 10032.3389
RB1_119 o1_119 iv1_119 10075.1104
XU1_119 n2_119 iv1_119 vcc vee o1_119 TL084
R3_119 o1_119 n3_119 2008.9278
R4_119 n3_119 n4_119 9938.8326
C3_119 n4_119 0 3.137432e-09
C4_119 out_119 n3_119 1.069249e-08
RA2_119 iv2_119 0 10025.3024
RB2_119 out_119 iv2_119 10012.0331
XU2_119 n4_119 iv2_119 vcc vee out_119 TL084
R1_120 in n1_120 3929.4633
R2_120 n1_120 n2_120 24146.7572
C1_120 n2_120 0 2.142277e-09
C2_120 o1_120 n1_120 3.438969e-09
RA1_120 iv1_120 0 9910.7561
RB1_120 o1_120 iv1_120 9912.0071
XU1_120 n2_120 iv1_120 vcc vee o1_120 TL084
R3_120 o1_120 n3_120 1980.3251
R4_120 n3_120 n4_120 10092.9044
C3_120 n4_120 0 2.980057e-09
C4_120 out_120 n3_120 9.597047e-09
RA2_120 iv2_120 0 9906.8531
RB2_120 out_120 iv2_120 9907.6549
XU2_120 n4_120 iv2_120 vcc vee out_120 TL084
R1_121 in n1_121 3936.7435
R2_121 n1_121 n2_121 24038.0129
C1_121 n2_121 0 2.011192e-09
C2_121 o1_121 n1_121 3.269120e-09
RA1_121 iv1_121 0 9945.9504
RB1_121 o1_121 iv1_121 10085.5767
XU1_121 n2_121 iv1_121 vcc vee o1_121 TL084
R3_121 o1_121 n3_121 1997.2127
R4_121 n3_121 n4_121 10036.5620
C3_121 n4_121 0 3.555329e-09
C4_121 out_121 n3_121 9.092342e-09
RA2_121 iv2_121 0 10026.5543
RB2_121 out_121 iv2_121 9947.5111
XU2_121 n4_121 iv2_121 vcc vee out_121 TL084
R1_122 in n1_122 3913.6153
R2_122 n1_122 n2_122 23975.5096
C1_122 n2_122 0 2.324781e-09
C2_122 o1_122 n1_122 3.324896e-09
RA1_122 iv1_122 0 9959.4363
RB1_122 o1_122 iv1_122 10007.3923
XU1_122 n2_122 iv1_122 vcc vee o1_122 TL084
R3_122 o1_122 n3_122 2001.3748
R4_122 n3_122 n4_122 10039.2245
C3_122 n4_122 0 3.549886e-09
C4_122 out_122 n3_122 9.468551e-09
RA2_122 iv2_122 0 9940.4856
RB2_122 out_122 iv2_122 9951.7129
XU2_122 n4_122 iv2_122 vcc vee out_122 TL084
R1_123 in n1_123 3924.1617
R2_123 n1_123 n2_123 23776.5571
C1_123 n2_123 0 2.018216e-09
C2_123 o1_123 n1_123 3.580383e-09
RA1_123 iv1_123 0 10014.2231
RB1_123 o1_123 iv1_123 10018.9686
XU1_123 n2_123 iv1_123 vcc vee o1_123 TL084
R3_123 o1_123 n3_123 1989.5814
R4_123 n3_123 n4_123 10044.4070
C3_123 n4_123 0 3.585133e-09
C4_123 out_123 n3_123 1.075496e-08
RA2_123 iv2_123 0 10055.2386
RB2_123 out_123 iv2_123 9906.8030
XU2_123 n4_123 iv2_123 vcc vee out_123 TL084
R1_124 in n1_124 3898.8837
R2_124 n1_124 n2_124 24002.6351
C1_124 n2_124 0 2.222883e-09
C2_124 o1_124 n1_124 3.522186e-09
RA1_124 iv1_124 0 10023.4871
RB1_124 o1_124 iv1_124 10028.2550
XU1_124 n2_124 iv1_124 vcc vee o1_124 TL084
R3_124 o1_124 n3_124 2017.2106
R4_124 n3_124 n4_124 9983.3763
C3_124 n4_124 0 3.374356e-09
C4_124 out_124 n3_124 9.566867e-09
RA2_124 iv2_124 0 9913.6932
RB2_124 out_124 iv2_124 9920.6103
XU2_124 n4_124 iv2_124 vcc vee out_124 TL084
R1_125 in n1_125 3885.1228
R2_125 n1_125 n2_125 23859.2167
C1_125 n2_125 0 2.326408e-09
C2_125 o1_125 n1_125 3.463080e-09
RA1_125 iv1_125 0 10043.5225
RB1_125 o1_125 iv1_125 10084.8318
XU1_125 n2_125 iv1_125 vcc vee o1_125 TL084
R3_125 o1_125 n3_125 1982.8779
R4_125 n3_125 n4_125 9936.5214
C3_125 n4_125 0 3.415232e-09
C4_125 out_125 n3_125 1.039367e-08
RA2_125 iv2_125 0 10044.7915
RB2_125 out_125 iv2_125 9904.4193
XU2_125 n4_125 iv2_125 vcc vee out_125 TL084
R1_126 in n1_126 3872.6383
R2_126 n1_126 n2_126 24211.7545
C1_126 n2_126 0 2.099071e-09
C2_126 o1_126 n1_126 3.323411e-09
RA1_126 iv1_126 0 10055.1582
RB1_126 o1_126 iv1_126 10059.8204
XU1_126 n2_126 iv1_126 vcc vee o1_126 TL084
R3_126 o1_126 n3_126 1994.5011
R4_126 n3_126 n4_126 10017.7890
C3_126 n4_126 0 3.290474e-09
C4_126 out_126 n3_126 9.589228e-09
RA2_126 iv2_126 0 9976.9795
RB2_126 out_126 iv2_126 10025.9415
XU2_126 n4_126 iv2_126 vcc vee out_126 TL084
R1_127 in n1_127 3889.7260
R2_127 n1_127 n2_127 24085.9674
C1_127 n2_127 0 2.028291e-09
C2_127 o1_127 n1_127 3.157736e-09
RA1_127 iv1_127 0 9946.1279
RB1_127 o1_127 iv1_127 9921.0430
XU1_127 n2_127 iv1_127 vcc vee o1_127 TL084
R3_127 o1_127 n3_127 1982.7128
R4_127 n3_127 n4_127 9919.7536
C3_127 n4_127 0 3.590961e-09
C4_127 out_127 n3_127 9.754090e-09
RA2_127 iv2_127 0 9995.9302
RB2_127 out_127 iv2_127 9910.1952
XU2_127 n4_127 iv2_127 vcc vee out_127 TL084
R1_128 in n1_128 3881.0837
R2_128 n1_128 n2_128 24138.5157
C1_128 n2_128 0 2.160514e-09
C2_128 o1_128 n1_128 3.087661e-09
RA1_128 iv1_128 0 9968.2319
RB1_128 o1_128 iv1_128 10028.2785
XU1_128 n2_128 iv1_128 vcc vee o1_128 TL084
R3_128 o1_128 n3_128 2004.2276
R4_128 n3_128 n4_128 10099.2512
C3_128 n4_128 0 3.411496e-09
C4_128 out_128 n3_128 9.798551e-09
RA2_128 iv2_128 0 9970.1261
RB2_128 out_128 iv2_128 10043.3558
XU2_128 n4_128 iv2_128 vcc vee out_128 TL084
R1_129 in n1_129 3934.9719
R2_129 n1_129 n2_129 23780.5948
C1_129 n2_129 0 2.036576e-09
C2_129 o1_129 n1_129 3.200625e-09
RA1_129 iv1_129 0 9952.0283
RB1_129 o1_129 iv1_129 9999.7703
XU1_129 n2_129 iv1_129 vcc vee o1_129 TL084
R3_129 o1_129 n3_129 1984.5206
R4_129 n3_129 n4_129 10037.4765
C3_129 n4_129 0 3.585562e-09
C4_129 out_129 n3_129 1.014936e-08
RA2_129 iv2_129 0 10061.7760
RB2_129 out_129 iv2_129 9924.8600
XU2_129 n4_129 iv2_129 vcc vee out_129 TL084
R1_130 in n1_130 3905.2416
R2_130 n1_130 n2_130 24163.6727
C1_130 n2_130 0 2.380201e-09
C2_130 o1_130 n1_130 3.069840e-09
RA1_130 iv1_130 0 9994.9598
RB1_130 o1_130 iv1_130 10089.1274
XU1_130 n2_130 iv1_130 vcc vee o1_130 TL084
R3_130 o1_130 n3_130 1994.9139
R4_130 n3_130 n4_130 10089.8583
C3_130 n4_130 0 3.443236e-09
C4_130 out_130 n3_130 1.056426e-08
RA2_130 iv2_130 0 9915.7483
RB2_130 out_130 iv2_130 9911.0553
XU2_130 n4_130 iv2_130 vcc vee out_130 TL084
R1_131 in n1_131 3879.2589
R2_131 n1_131 n2_131 24202.5981
C1_131 n2_131 0 2.357813e-09
C2_131 o1_131 n1_131 3.167848e-09
RA1_131 iv1_131 0 9930.0017
RB1_131 o1_131 iv1_131 10092.9821
XU1_131 n2_131 iv1_131 vcc vee o1_131 TL084
R3_131 o1_131 n3_131 1982.1179
R4_131 n3_131 n4_131 9984.2015
C3_131 n4_131 0 3.526551e-09
C4_131 out_131 n3_131 9.237536e-09
RA2_131 iv2_131 0 9903.7835
RB2_131 out_131 iv2_131 9948.9314
XU2_131 n4_131 iv2_131 vcc vee out_131 TL084
R1_132 in n1_132 3919.5304
R2_132 n1_132 n2_132 24070.4239
C1_132 n2_132 0 2.345912e-09
C2_132 o1_132 n1_132 3.290896e-09
RA1_132 iv1_132 0 10000.5616
RB1_132 o1_132 iv1_132 10069.3272
XU1_132 n2_132 iv1_132 vcc vee o1_132 TL084
R3_132 o1_132 n3_132 1993.0827
R4_132 n3_132 n4_132 9967.9152
C3_132 n4_132 0 3.388500e-09
C4_132 out_132 n3_132 9.848841e-09
RA2_132 iv2_132 0 9999.4300
RB2_132 out_132 iv2_132 10023.2268
XU2_132 n4_132 iv2_132 vcc vee out_132 TL084
R1_133 in n1_133 3909.7589
R2_133 n1_133 n2_133 23791.6681
C1_133 n2_133 0 2.200450e-09
C2_133 o1_133 n1_133 3.195400e-09
RA1_133 iv1_133 0 9936.5124
RB1_133 o1_133 iv1_133 9978.6108
XU1_133 n2_133 iv1_133 vcc vee o1_133 TL084
R3_133 o1_133 n3_133 2015.3365
R4_133 n3_133 n4_133 9976.4229
C3_133 n4_133 0 3.006262e-09
C4_133 out_133 n3_133 9.078769e-09
RA2_133 iv2_133 0 10034.1324
RB2_133 out_133 iv2_133 10094.0182
XU2_133 n4_133 iv2_133 vcc vee out_133 TL084
R1_134 in n1_134 3911.8888
R2_134 n1_134 n2_134 24129.0226
C1_134 n2_134 0 2.090981e-09
C2_134 o1_134 n1_134 3.591076e-09
RA1_134 iv1_134 0 10040.7247
RB1_134 o1_134 iv1_134 10067.0921
XU1_134 n2_134 iv1_134 vcc vee o1_134 TL084
R3_134 o1_134 n3_134 1994.9787
R4_134 n3_134 n4_134 9965.3769
C3_134 n4_134 0 3.192198e-09
C4_134 out_134 n3_134 9.781941e-09
RA2_134 iv2_134 0 9939.4189
RB2_134 out_134 iv2_134 9994.8457
XU2_134 n4_134 iv2_134 vcc vee out_134 TL084
R1_135 in n1_135 3903.9957
R2_135 n1_135 n2_135 24080.0107
C1_135 n2_135 0 1.981338e-09
C2_135 o1_135 n1_135 3.506754e-09
RA1_135 iv1_135 0 9989.1176
RB1_135 o1_135 iv1_135 10088.4019
XU1_135 n2_135 iv1_135 vcc vee o1_135 TL084
R3_135 o1_135 n3_135 1982.7148
R4_135 n3_135 n4_135 10012.5742
C3_135 n4_135 0 3.296435e-09
C4_135 out_135 n3_135 9.438530e-09
RA2_135 iv2_135 0 9978.7170
RB2_135 out_135 iv2_135 9954.5138
XU2_135 n4_135 iv2_135 vcc vee out_135 TL084
R1_136 in n1_136 3927.1056
R2_136 n1_136 n2_136 24090.7561
C1_136 n2_136 0 2.315525e-09
C2_136 o1_136 n1_136 3.397712e-09
RA1_136 iv1_136 0 9933.0372
RB1_136 o1_136 iv1_136 9970.1491
XU1_136 n2_136 iv1_136 vcc vee o1_136 TL084
R3_136 o1_136 n3_136 1984.1108
R4_136 n3_136 n4_136 10051.3405
C3_136 n4_136 0 2.980730e-09
C4_136 out_136 n3_136 1.054272e-08
RA2_136 iv2_136 0 10074.9430
RB2_136 out_136 iv2_136 10054.4745
XU2_136 n4_136 iv2_136 vcc vee out_136 TL084
R1_137 in n1_137 3908.6483
R2_137 n1_137 n2_137 24098.8039
C1_137 n2_137 0 2.375680e-09
C2_137 o1_137 n1_137 3.324852e-09
RA1_137 iv1_137 0 9915.2625
RB1_137 o1_137 iv1_137 9968.8030
XU1_137 n2_137 iv1_137 vcc vee o1_137 TL084
R3_137 o1_137 n3_137 1996.4091
R4_137 n3_137 n4_137 10030.2348
C3_137 n4_137 0 3.521219e-09
C4_137 out_137 n3_137 1.007947e-08
RA2_137 iv2_137 0 9985.1151
RB2_137 out_137 iv2_137 9905.2285
XU2_137 n4_137 iv2_137 vcc vee out_137 TL084
R1_138 in n1_138 3911.3216
R2_138 n1_138 n2_138 24174.0162
C1_138 n2_138 0 2.200435e-09
C2_138 o1_138 n1_138 3.443086e-09
RA1_138 iv1_138 0 10056.4765
RB1_138 o1_138 iv1_138 9939.6241
XU1_138 n2_138 iv1_138 vcc vee o1_138 TL084
R3_138 o1_138 n3_138 2013.1406
R4_138 n3_138 n4_138 9928.0583
C3_138 n4_138 0 3.550475e-09
C4_138 out_138 n3_138 1.072236e-08
RA2_138 iv2_138 0 9960.9210
RB2_138 out_138 iv2_138 9979.3277
XU2_138 n4_138 iv2_138 vcc vee out_138 TL084
R1_139 in n1_139 3930.4344
R2_139 n1_139 n2_139 24189.6286
C1_139 n2_139 0 2.250188e-09
C2_139 o1_139 n1_139 3.166921e-09
RA1_139 iv1_139 0 10082.5895
RB1_139 o1_139 iv1_139 9981.9521
XU1_139 n2_139 iv1_139 vcc vee o1_139 TL084
R3_139 o1_139 n3_139 1985.6141
R4_139 n3_139 n4_139 10050.9343
C3_139 n4_139 0 3.224725e-09
C4_139 out_139 n3_139 1.076775e-08
RA2_139 iv2_139 0 9947.4939
RB2_139 out_139 iv2_139 10096.5876
XU2_139 n4_139 iv2_139 vcc vee out_139 TL084
R1_140 in n1_140 3901.1591
R2_140 n1_140 n2_140 23999.5298
C1_140 n2_140 0 2.092188e-09
C2_140 o1_140 n1_140 3.056760e-09
RA1_140 iv1_140 0 10063.9071
RB1_140 o1_140 iv1_140 10075.3209
XU1_140 n2_140 iv1_140 vcc vee o1_140 TL084
R3_140 o1_140 n3_140 2004.4495
R4_140 n3_140 n4_140 10002.4548
C3_140 n4_140 0 3.148761e-09
C4_140 out_140 n3_140 1.056550e-08
RA2_140 iv2_140 0 9988.1022
RB2_140 out_140 iv2_140 10047.9773
XU2_140 n4_140 iv2_140 vcc vee out_140 TL084
R1_141 in n1_141 3883.0079
R2_141 n1_141 n2_141 23907.3169
C1_141 n2_141 0 2.256045e-09
C2_141 o1_141 n1_141 3.300574e-09
RA1_141 iv1_141 0 10065.6201
RB1_141 o1_141 iv1_141 9935.5996
XU1_141 n2_141 iv1_141 vcc vee o1_141 TL084
R3_141 o1_141 n3_141 2018.8478
R4_141 n3_141 n4_141 9919.2338
C3_141 n4_141 0 3.168992e-09
C4_141 out_141 n3_141 1.084470e-08
RA2_141 iv2_141 0 9941.4894
RB2_141 out_141 iv2_141 9962.7354
XU2_141 n4_141 iv2_141 vcc vee out_141 TL084
R1_142 in n1_142 3924.7740
R2_142 n1_142 n2_142 23784.1965
C1_142 n2_142 0 2.101181e-09
C2_142 o1_142 n1_142 3.443430e-09
RA1_142 iv1_142 0 9941.6242
RB1_142 o1_142 iv1_142 10072.9946
XU1_142 n2_142 iv1_142 vcc vee o1_142 TL084
R3_142 o1_142 n3_142 2013.0411
R4_142 n3_142 n4_142 10071.1129
C3_142 n4_142 0 3.131477e-09
C4_142 out_142 n3_142 1.013056e-08
RA2_142 iv2_142 0 9921.9232
RB2_142 out_142 iv2_142 9990.9990
XU2_142 n4_142 iv2_142 vcc vee out_142 TL084
R1_143 in n1_143 3932.4176
R2_143 n1_143 n2_143 23794.9244
C1_143 n2_143 0 2.190622e-09
C2_143 o1_143 n1_143 3.287070e-09
RA1_143 iv1_143 0 9991.5751
RB1_143 o1_143 iv1_143 10057.2908
XU1_143 n2_143 iv1_143 vcc vee o1_143 TL084
R3_143 o1_143 n3_143 2011.0479
R4_143 n3_143 n4_143 9974.3530
C3_143 n4_143 0 3.086950e-09
C4_143 out_143 n3_143 9.575229e-09
RA2_143 iv2_143 0 9952.8335
RB2_143 out_143 iv2_143 9928.4294
XU2_143 n4_143 iv2_143 vcc vee out_143 TL084
R1_144 in n1_144 3909.9349
R2_144 n1_144 n2_144 24159.0102
C1_144 n2_144 0 2.350549e-09
C2_144 o1_144 n1_144 3.235832e-09
RA1_144 iv1_144 0 10004.6513
RB1_144 o1_144 iv1_144 10076.9228
XU1_144 n2_144 iv1_144 vcc vee o1_144 TL084
R3_144 o1_144 n3_144 2017.3665
R4_144 n3_144 n4_144 10036.8580
C3_144 n4_144 0 3.466220e-09
C4_144 out_144 n3_144 9.925441e-09
RA2_144 iv2_144 0 10040.3032
RB2_144 out_144 iv2_144 9906.4470
XU2_144 n4_144 iv2_144 vcc vee out_144 TL084
R1_145 in n1_145 3884.8541
R2_145 n1_145 n2_145 23788.2167
C1_145 n2_145 0 2.261216e-09
C2_145 o1_145 n1_145 3.056494e-09
RA1_145 iv1_145 0 9999.3647
RB1_145 o1_145 iv1_145 10079.3689
XU1_145 n2_145 iv1_145 vcc vee o1_145 TL084
R3_145 o1_145 n3_145 2008.7028
R4_145 n3_145 n4_145 9925.1337
C3_145 n4_145 0 3.411409e-09
C4_145 out_145 n3_145 9.300022e-09
RA2_145 iv2_145 0 9939.0575
RB2_145 out_145 iv2_145 9976.2824
XU2_145 n4_145 iv2_145 vcc vee out_145 TL084
R1_146 in n1_146 3898.5551
R2_146 n1_146 n2_146 24012.6852
C1_146 n2_146 0 2.117038e-09
C2_146 o1_146 n1_146 3.438807e-09
RA1_146 iv1_146 0 10098.0284
RB1_146 o1_146 iv1_146 10092.9446
XU1_146 n2_146 iv1_146 vcc vee o1_146 TL084
R3_146 o1_146 n3_146 2017.2885
R4_146 n3_146 n4_146 9919.4537
C3_146 n4_146 0 3.508127e-09
C4_146 out_146 n3_146 9.249813e-09
RA2_146 iv2_146 0 10000.4905
RB2_146 out_146 iv2_146 10079.1335
XU2_146 n4_146 iv2_146 vcc vee out_146 TL084
R1_147 in n1_147 3923.1298
R2_147 n1_147 n2_147 24213.3085
C1_147 n2_147 0 2.231286e-09
C2_147 o1_147 n1_147 3.033767e-09
RA1_147 iv1_147 0 9947.8906
RB1_147 o1_147 iv1_147 10089.3320
XU1_147 n2_147 iv1_147 vcc vee o1_147 TL084
R3_147 o1_147 n3_147 1985.5924
R4_147 n3_147 n4_147 9975.0551
C3_147 n4_147 0 3.518690e-09
C4_147 out_147 n3_147 9.860447e-09
RA2_147 iv2_147 0 9949.6907
RB2_147 out_147 iv2_147 9935.1178
XU2_147 n4_147 iv2_147 vcc vee out_147 TL084
R1_148 in n1_148 3896.0155
R2_148 n1_148 n2_148 23862.2285
C1_148 n2_148 0 2.380821e-09
C2_148 o1_148 n1_148 3.150713e-09
RA1_148 iv1_148 0 10052.3309
RB1_148 o1_148 iv1_148 9977.3257
XU1_148 n2_148 iv1_148 vcc vee o1_148 TL084
R3_148 o1_148 n3_148 1986.2785
R4_148 n3_148 n4_148 10034.8192
C3_148 n4_148 0 3.621659e-09
C4_148 out_148 n3_148 9.676988e-09
RA2_148 iv2_148 0 10053.5798
RB2_148 out_148 iv2_148 10073.9549
XU2_148 n4_148 iv2_148 vcc vee out_148 TL084
R1_149 in n1_149 3913.7993
R2_149 n1_149 n2_149 23984.5841
C1_149 n2_149 0 2.225020e-09
C2_149 o1_149 n1_149 3.115176e-09
RA1_149 iv1_149 0 10075.2139
RB1_149 o1_149 iv1_149 10005.0934
XU1_149 n2_149 iv1_149 vcc vee o1_149 TL084
R3_149 o1_149 n3_149 2003.2221
R4_149 n3_149 n4_149 9996.3204
C3_149 n4_149 0 3.570828e-09
C4_149 out_149 n3_149 9.945539e-09
RA2_149 iv2_149 0 9924.9048
RB2_149 out_149 iv2_149 9969.7884
XU2_149 n4_149 iv2_149 vcc vee out_149 TL084
R1_150 in n1_150 3910.0311
R2_150 n1_150 n2_150 23860.2832
C1_150 n2_150 0 2.111749e-09
C2_150 o1_150 n1_150 3.307880e-09
RA1_150 iv1_150 0 10003.7063
RB1_150 o1_150 iv1_150 10097.5587
XU1_150 n2_150 iv1_150 vcc vee o1_150 TL084
R3_150 o1_150 n3_150 2003.8771
R4_150 n3_150 n4_150 10064.6698
C3_150 n4_150 0 3.118739e-09
C4_150 out_150 n3_150 1.041062e-08
RA2_150 iv2_150 0 10031.7973
RB2_150 out_150 iv2_150 10016.4844
XU2_150 n4_150 iv2_150 vcc vee out_150 TL084
R1_151 in n1_151 3922.2995
R2_151 n1_151 n2_151 23863.1740
C1_151 n2_151 0 2.094262e-09
C2_151 o1_151 n1_151 3.398151e-09
RA1_151 iv1_151 0 10031.3754
RB1_151 o1_151 iv1_151 9904.8721
XU1_151 n2_151 iv1_151 vcc vee o1_151 TL084
R3_151 o1_151 n3_151 2014.8336
R4_151 n3_151 n4_151 9993.1897
C3_151 n4_151 0 3.168952e-09
C4_151 out_151 n3_151 9.184070e-09
RA2_151 iv2_151 0 10022.2766
RB2_151 out_151 iv2_151 10074.5881
XU2_151 n4_151 iv2_151 vcc vee out_151 TL084
R1_152 in n1_152 3904.0502
R2_152 n1_152 n2_152 23763.6633
C1_152 n2_152 0 2.352280e-09
C2_152 o1_152 n1_152 2.995015e-09
RA1_152 iv1_152 0 10060.9894
RB1_152 o1_152 iv1_152 10031.3621
XU1_152 n2_152 iv1_152 vcc vee o1_152 TL084
R3_152 o1_152 n3_152 2007.8422
R4_152 n3_152 n4_152 9917.5961
C3_152 n4_152 0 3.538375e-09
C4_152 out_152 n3_152 9.612087e-09
RA2_152 iv2_152 0 10010.0417
RB2_152 out_152 iv2_152 10076.6705
XU2_152 n4_152 iv2_152 vcc vee out_152 TL084
R1_153 in n1_153 3904.3476
R2_153 n1_153 n2_153 24000.7609
C1_153 n2_153 0 2.024842e-09
C2_153 o1_153 n1_153 3.450060e-09
RA1_153 iv1_153 0 10041.2733
RB1_153 o1_153 iv1_153 9956.6297
XU1_153 n2_153 iv1_153 vcc vee o1_153 TL084
R3_153 o1_153 n3_153 2004.9416
R4_153 n3_153 n4_153 10019.4803
C3_153 n4_153 0 3.501896e-09
C4_153 out_153 n3_153 1.067189e-08
RA2_153 iv2_153 0 9993.3692
RB2_153 out_153 iv2_153 9904.1536
XU2_153 n4_153 iv2_153 vcc vee out_153 TL084
R1_154 in n1_154 3880.5663
R2_154 n1_154 n2_154 24226.8656
C1_154 n2_154 0 2.118953e-09
C2_154 o1_154 n1_154 3.410833e-09
RA1_154 iv1_154 0 10035.4670
RB1_154 o1_154 iv1_154 9995.3731
XU1_154 n2_154 iv1_154 vcc vee o1_154 TL084
R3_154 o1_154 n3_154 2015.4262
R4_154 n3_154 n4_154 10094.1388
C3_154 n4_154 0 3.629611e-09
C4_154 out_154 n3_154 1.090470e-08
RA2_154 iv2_154 0 9921.3317
RB2_154 out_154 iv2_154 10036.9981
XU2_154 n4_154 iv2_154 vcc vee out_154 TL084
R1_155 in n1_155 3912.2506
R2_155 n1_155 n2_155 24230.6063
C1_155 n2_155 0 2.389469e-09
C2_155 o1_155 n1_155 3.224693e-09
RA1_155 iv1_155 0 10013.6630
RB1_155 o1_155 iv1_155 10053.0087
XU1_155 n2_155 iv1_155 vcc vee o1_155 TL084
R3_155 o1_155 n3_155 2015.1828
R4_155 n3_155 n4_155 10080.7583
C3_155 n4_155 0 3.266176e-09
C4_155 out_155 n3_155 1.056331e-08
RA2_155 iv2_155 0 9974.0080
RB2_155 out_155 iv2_155 9927.8025
XU2_155 n4_155 iv2_155 vcc vee out_155 TL084
R1_156 in n1_156 3885.7485
R2_156 n1_156 n2_156 23913.9107
C1_156 n2_156 0 2.057668e-09
C2_156 o1_156 n1_156 3.224133e-09
RA1_156 iv1_156 0 9942.4947
RB1_156 o1_156 iv1_156 9917.8070
XU1_156 n2_156 iv1_156 vcc vee o1_156 TL084
R3_156 o1_156 n3_156 2008.0125
R4_156 n3_156 n4_156 10071.0048
C3_156 n4_156 0 3.169443e-09
C4_156 out_156 n3_156 1.008265e-08
RA2_156 iv2_156 0 9981.5184
RB2_156 out_156 iv2_156 10020.2491
XU2_156 n4_156 iv2_156 vcc vee out_156 TL084
R1_157 in n1_157 3931.0903
R2_157 n1_157 n2_157 23820.5435
C1_157 n2_157 0 2.054598e-09
C2_157 o1_157 n1_157 3.398414e-09
RA1_157 iv1_157 0 9916.8002
RB1_157 o1_157 iv1_157 9974.2940
XU1_157 n2_157 iv1_157 vcc vee o1_157 TL084
R3_157 o1_157 n3_157 1990.5884
R4_157 n3_157 n4_157 10032.9327
C3_157 n4_157 0 3.566288e-09
C4_157 out_157 n3_157 9.866672e-09
RA2_157 iv2_157 0 10090.0737
RB2_157 out_157 iv2_157 10038.0158
XU2_157 n4_157 iv2_157 vcc vee out_157 TL084
R1_158 in n1_158 3868.7503
R2_158 n1_158 n2_158 24230.0117
C1_158 n2_158 0 2.337337e-09
C2_158 o1_158 n1_158 3.215249e-09
RA1_158 iv1_158 0 10086.4575
RB1_158 o1_158 iv1_158 9981.1266
XU1_158 n2_158 iv1_158 vcc vee o1_158 TL084
R3_158 o1_158 n3_158 2000.4843
R4_158 n3_158 n4_158 9935.7467
C3_158 n4_158 0 3.441404e-09
C4_158 out_158 n3_158 9.699612e-09
RA2_158 iv2_158 0 10084.0977
RB2_158 out_158 iv2_158 10041.4226
XU2_158 n4_158 iv2_158 vcc vee out_158 TL084
R1_159 in n1_159 3902.3582
R2_159 n1_159 n2_159 23823.0591
C1_159 n2_159 0 2.417798e-09
C2_159 o1_159 n1_159 3.506175e-09
RA1_159 iv1_159 0 10074.0724
RB1_159 o1_159 iv1_159 9905.5427
XU1_159 n2_159 iv1_159 vcc vee o1_159 TL084
R3_159 o1_159 n3_159 1994.6951
R4_159 n3_159 n4_159 10051.2686
C3_159 n4_159 0 3.392753e-09
C4_159 out_159 n3_159 1.095431e-08
RA2_159 iv2_159 0 9955.4606
RB2_159 out_159 iv2_159 9980.8696
XU2_159 n4_159 iv2_159 vcc vee out_159 TL084
R1_160 in n1_160 3925.8615
R2_160 n1_160 n2_160 23786.5671
C1_160 n2_160 0 2.345076e-09
C2_160 o1_160 n1_160 3.599837e-09
RA1_160 iv1_160 0 10046.3679
RB1_160 o1_160 iv1_160 9998.8650
XU1_160 n2_160 iv1_160 vcc vee o1_160 TL084
R3_160 o1_160 n3_160 2010.3063
R4_160 n3_160 n4_160 9911.0462
C3_160 n4_160 0 3.591698e-09
C4_160 out_160 n3_160 1.057305e-08
RA2_160 iv2_160 0 9973.2029
RB2_160 out_160 iv2_160 10000.5998
XU2_160 n4_160 iv2_160 vcc vee out_160 TL084
R1_161 in n1_161 3911.0831
R2_161 n1_161 n2_161 24094.9851
C1_161 n2_161 0 1.984585e-09
C2_161 o1_161 n1_161 3.462319e-09
RA1_161 iv1_161 0 9904.8683
RB1_161 o1_161 iv1_161 9947.8909
XU1_161 n2_161 iv1_161 vcc vee o1_161 TL084
R3_161 o1_161 n3_161 2018.0153
R4_161 n3_161 n4_161 9905.8275
C3_161 n4_161 0 3.224927e-09
C4_161 out_161 n3_161 9.316641e-09
RA2_161 iv2_161 0 10005.4297
RB2_161 out_161 iv2_161 9975.8007
XU2_161 n4_161 iv2_161 vcc vee out_161 TL084
R1_162 in n1_162 3873.1495
R2_162 n1_162 n2_162 23980.2186
C1_162 n2_162 0 2.127067e-09
C2_162 o1_162 n1_162 3.081580e-09
RA1_162 iv1_162 0 9955.5213
RB1_162 o1_162 iv1_162 10092.6418
XU1_162 n2_162 iv1_162 vcc vee o1_162 TL084
R3_162 o1_162 n3_162 1991.2501
R4_162 n3_162 n4_162 10051.1112
C3_162 n4_162 0 3.569477e-09
C4_162 out_162 n3_162 1.084833e-08
RA2_162 iv2_162 0 10077.3070
RB2_162 out_162 iv2_162 9901.9338
XU2_162 n4_162 iv2_162 vcc vee out_162 TL084
R1_163 in n1_163 3890.1477
R2_163 n1_163 n2_163 23822.0450
C1_163 n2_163 0 2.090825e-09
C2_163 o1_163 n1_163 3.422683e-09
RA1_163 iv1_163 0 10000.2340
RB1_163 o1_163 iv1_163 9971.2737
XU1_163 n2_163 iv1_163 vcc vee o1_163 TL084
R3_163 o1_163 n3_163 1991.4435
R4_163 n3_163 n4_163 10008.7140
C3_163 n4_163 0 3.193645e-09
C4_163 out_163 n3_163 1.079092e-08
RA2_163 iv2_163 0 9995.5121
RB2_163 out_163 iv2_163 10039.0277
XU2_163 n4_163 iv2_163 vcc vee out_163 TL084
R1_164 in n1_164 3917.4810
R2_164 n1_164 n2_164 24128.1670
C1_164 n2_164 0 2.227241e-09
C2_164 o1_164 n1_164 3.462722e-09
RA1_164 iv1_164 0 10068.7623
RB1_164 o1_164 iv1_164 9990.1918
XU1_164 n2_164 iv1_164 vcc vee o1_164 TL084
R3_164 o1_164 n3_164 2002.8296
R4_164 n3_164 n4_164 9974.6650
C3_164 n4_164 0 3.041289e-09
C4_164 out_164 n3_164 1.022777e-08
RA2_164 iv2_164 0 9999.2138
RB2_164 out_164 iv2_164 9907.4746
XU2_164 n4_164 iv2_164 vcc vee out_164 TL084
R1_165 in n1_165 3904.7591
R2_165 n1_165 n2_165 24147.9267
C1_165 n2_165 0 1.991302e-09
C2_165 o1_165 n1_165 3.455357e-09
RA1_165 iv1_165 0 10028.0520
RB1_165 o1_165 iv1_165 10002.4280
XU1_165 n2_165 iv1_165 vcc vee o1_165 TL084
R3_165 o1_165 n3_165 2007.6165
R4_165 n3_165 n4_165 9996.9742
C3_165 n4_165 0 3.269134e-09
C4_165 out_165 n3_165 1.045646e-08
RA2_165 iv2_165 0 9916.0865
RB2_165 out_165 iv2_165 9918.7968
XU2_165 n4_165 iv2_165 vcc vee out_165 TL084
R1_166 in n1_166 3929.5605
R2_166 n1_166 n2_166 24102.0135
C1_166 n2_166 0 2.179790e-09
C2_166 o1_166 n1_166 3.026807e-09
RA1_166 iv1_166 0 10075.9899
RB1_166 o1_166 iv1_166 10073.8311
XU1_166 n2_166 iv1_166 vcc vee o1_166 TL084
R3_166 o1_166 n3_166 1985.6683
R4_166 n3_166 n4_166 9939.9515
C3_166 n4_166 0 3.375838e-09
C4_166 out_166 n3_166 1.091162e-08
RA2_166 iv2_166 0 9995.3565
RB2_166 out_166 iv2_166 9904.4254
XU2_166 n4_166 iv2_166 vcc vee out_166 TL084
R1_167 in n1_167 3896.9568
R2_167 n1_167 n2_167 23791.6912
C1_167 n2_167 0 2.155811e-09
C2_167 o1_167 n1_167 3.169587e-09
RA1_167 iv1_167 0 9972.7416
RB1_167 o1_167 iv1_167 10023.4959
XU1_167 n2_167 iv1_167 vcc vee o1_167 TL084
R3_167 o1_167 n3_167 1985.9738
R4_167 n3_167 n4_167 10082.7469
C3_167 n4_167 0 3.127284e-09
C4_167 out_167 n3_167 9.418005e-09
RA2_167 iv2_167 0 9990.8141
RB2_167 out_167 iv2_167 9962.8337
XU2_167 n4_167 iv2_167 vcc vee out_167 TL084
R1_168 in n1_168 3931.0911
R2_168 n1_168 n2_168 24159.8042
C1_168 n2_168 0 2.281404e-09
C2_168 o1_168 n1_168 3.583601e-09
RA1_168 iv1_168 0 10045.1136
RB1_168 o1_168 iv1_168 9949.7750
XU1_168 n2_168 iv1_168 vcc vee o1_168 TL084
R3_168 o1_168 n3_168 2013.8482
R4_168 n3_168 n4_168 9937.9149
C3_168 n4_168 0 3.567883e-09
C4_168 out_168 n3_168 1.079663e-08
RA2_168 iv2_168 0 10074.0705
RB2_168 out_168 iv2_168 10019.6505
XU2_168 n4_168 iv2_168 vcc vee out_168 TL084
R1_169 in n1_169 3863.0625
R2_169 n1_169 n2_169 24079.0042
C1_169 n2_169 0 2.207385e-09
C2_169 o1_169 n1_169 3.199853e-09
RA1_169 iv1_169 0 10043.1836
RB1_169 o1_169 iv1_169 9957.5192
XU1_169 n2_169 iv1_169 vcc vee o1_169 TL084
R3_169 o1_169 n3_169 1982.5876
R4_169 n3_169 n4_169 9944.2026
C3_169 n4_169 0 2.998992e-09
C4_169 out_169 n3_169 1.002059e-08
RA2_169 iv2_169 0 9990.8242
RB2_169 out_169 iv2_169 9951.7755
XU2_169 n4_169 iv2_169 vcc vee out_169 TL084
R1_170 in n1_170 3928.8554
R2_170 n1_170 n2_170 24020.9537
C1_170 n2_170 0 2.396354e-09
C2_170 o1_170 n1_170 3.274941e-09
RA1_170 iv1_170 0 9933.6085
RB1_170 o1_170 iv1_170 9956.6673
XU1_170 n2_170 iv1_170 vcc vee o1_170 TL084
R3_170 o1_170 n3_170 1995.5926
R4_170 n3_170 n4_170 10003.2073
C3_170 n4_170 0 3.048273e-09
C4_170 out_170 n3_170 9.959203e-09
RA2_170 iv2_170 0 10046.9264
RB2_170 out_170 iv2_170 10005.7157
XU2_170 n4_170 iv2_170 vcc vee out_170 TL084
R1_171 in n1_171 3901.5853
R2_171 n1_171 n2_171 23969.5744
C1_171 n2_171 0 2.048736e-09
C2_171 o1_171 n1_171 3.203862e-09
RA1_171 iv1_171 0 9910.0614
RB1_171 o1_171 iv1_171 9971.8148
XU1_171 n2_171 iv1_171 vcc vee o1_171 TL084
R3_171 o1_171 n3_171 2001.1084
R4_171 n3_171 n4_171 9909.8625
C3_171 n4_171 0 3.432356e-09
C4_171 out_171 n3_171 9.877643e-09
RA2_171 iv2_171 0 9944.3127
RB2_171 out_171 iv2_171 10067.0502
XU2_171 n4_171 iv2_171 vcc vee out_171 TL084
R1_172 in n1_172 3927.8007
R2_172 n1_172 n2_172 23863.5846
C1_172 n2_172 0 2.078948e-09
C2_172 o1_172 n1_172 3.331770e-09
RA1_172 iv1_172 0 9933.8661
RB1_172 o1_172 iv1_172 9964.2289
XU1_172 n2_172 iv1_172 vcc vee o1_172 TL084
R3_172 o1_172 n3_172 2010.1903
R4_172 n3_172 n4_172 9904.6127
C3_172 n4_172 0 3.339141e-09
C4_172 out_172 n3_172 9.529775e-09
RA2_172 iv2_172 0 10082.5018
RB2_172 out_172 iv2_172 9976.9340
XU2_172 n4_172 iv2_172 vcc vee out_172 TL084
R1_173 in n1_173 3930.5231
R2_173 n1_173 n2_173 23870.9794
C1_173 n2_173 0 2.233094e-09
C2_173 o1_173 n1_173 3.124619e-09
RA1_173 iv1_173 0 10036.5599
RB1_173 o1_173 iv1_173 10074.7480
XU1_173 n2_173 iv1_173 vcc vee o1_173 TL084
R3_173 o1_173 n3_173 2018.8092
R4_173 n3_173 n4_173 9981.9462
C3_173 n4_173 0 2.974893e-09
C4_173 out_173 n3_173 1.085401e-08
RA2_173 iv2_173 0 10075.5231
RB2_173 out_173 iv2_173 10032.4716
XU2_173 n4_173 iv2_173 vcc vee out_173 TL084
R1_174 in n1_174 3906.1512
R2_174 n1_174 n2_174 23791.6935
C1_174 n2_174 0 2.017049e-09
C2_174 o1_174 n1_174 3.597750e-09
RA1_174 iv1_174 0 9916.0184
RB1_174 o1_174 iv1_174 10075.2728
XU1_174 n2_174 iv1_174 vcc vee o1_174 TL084
R3_174 o1_174 n3_174 2015.8291
R4_174 n3_174 n4_174 9947.1301
C3_174 n4_174 0 2.986823e-09
C4_174 out_174 n3_174 9.978652e-09
RA2_174 iv2_174 0 10090.7436
RB2_174 out_174 iv2_174 9923.9471
XU2_174 n4_174 iv2_174 vcc vee out_174 TL084
R1_175 in n1_175 3912.6859
R2_175 n1_175 n2_175 24091.4483
C1_175 n2_175 0 1.986690e-09
C2_175 o1_175 n1_175 3.097086e-09
RA1_175 iv1_175 0 9989.6144
RB1_175 o1_175 iv1_175 9960.6564
XU1_175 n2_175 iv1_175 vcc vee o1_175 TL084
R3_175 o1_175 n3_175 1994.2767
R4_175 n3_175 n4_175 9923.0009
C3_175 n4_175 0 3.395652e-09
C4_175 out_175 n3_175 9.549232e-09
RA2_175 iv2_175 0 10019.0173
RB2_175 out_175 iv2_175 10051.9114
XU2_175 n4_175 iv2_175 vcc vee out_175 TL084
R1_176 in n1_176 3912.7852
R2_176 n1_176 n2_176 24147.5455
C1_176 n2_176 0 2.045225e-09
C2_176 o1_176 n1_176 3.567073e-09
RA1_176 iv1_176 0 9937.7515
RB1_176 o1_176 iv1_176 10061.9275
XU1_176 n2_176 iv1_176 vcc vee o1_176 TL084
R3_176 o1_176 n3_176 2015.1413
R4_176 n3_176 n4_176 10049.5636
C3_176 n4_176 0 3.384029e-09
C4_176 out_176 n3_176 9.965877e-09
RA2_176 iv2_176 0 10007.8798
RB2_176 out_176 iv2_176 9978.9188
XU2_176 n4_176 iv2_176 vcc vee out_176 TL084
R1_177 in n1_177 3936.2338
R2_177 n1_177 n2_177 24189.2177
C1_177 n2_177 0 1.991064e-09
C2_177 o1_177 n1_177 3.185871e-09
RA1_177 iv1_177 0 9999.0637
RB1_177 o1_177 iv1_177 9976.2318
XU1_177 n2_177 iv1_177 vcc vee o1_177 TL084
R3_177 o1_177 n3_177 2005.8983
R4_177 n3_177 n4_177 10065.8811
C3_177 n4_177 0 3.158684e-09
C4_177 out_177 n3_177 9.447581e-09
RA2_177 iv2_177 0 10000.1947
RB2_177 out_177 iv2_177 10067.9895
XU2_177 n4_177 iv2_177 vcc vee out_177 TL084
R1_178 in n1_178 3881.3843
R2_178 n1_178 n2_178 24008.3853
C1_178 n2_178 0 2.226394e-09
C2_178 o1_178 n1_178 3.092753e-09
RA1_178 iv1_178 0 9993.3296
RB1_178 o1_178 iv1_178 9918.3892
XU1_178 n2_178 iv1_178 vcc vee o1_178 TL084
R3_178 o1_178 n3_178 1999.1406
R4_178 n3_178 n4_178 10045.8268
C3_178 n4_178 0 3.414702e-09
C4_178 out_178 n3_178 9.902628e-09
RA2_178 iv2_178 0 10079.2268
RB2_178 out_178 iv2_178 9913.0940
XU2_178 n4_178 iv2_178 vcc vee out_178 TL084
R1_179 in n1_179 3933.4668
R2_179 n1_179 n2_179 24131.8886
C1_179 n2_179 0 2.417118e-09
C2_179 o1_179 n1_179 3.344673e-09
RA1_179 iv1_179 0 10015.7048
RB1_179 o1_179 iv1_179 10025.8395
XU1_179 n2_179 iv1_179 vcc vee o1_179 TL084
R3_179 o1_179 n3_179 2001.4492
R4_179 n3_179 n4_179 9933.6457
C3_179 n4_179 0 3.096345e-09
C4_179 out_179 n3_179 9.375601e-09
RA2_179 iv2_179 0 10027.4614
RB2_179 out_179 iv2_179 9935.6922
XU2_179 n4_179 iv2_179 vcc vee out_179 TL084
R1_180 in n1_180 3865.1727
R2_180 n1_180 n2_180 23869.9221
C1_180 n2_180 0 2.063604e-09
C2_180 o1_180 n1_180 3.024578e-09
RA1_180 iv1_180 0 9990.9205
RB1_180 o1_180 iv1_180 10060.9212
XU1_180 n2_180 iv1_180 vcc vee o1_180 TL084
R3_180 o1_180 n3_180 2007.9319
R4_180 n3_180 n4_180 10093.1161
C3_180 n4_180 0 2.989726e-09
C4_180 out_180 n3_180 9.567594e-09
RA2_180 iv2_180 0 10094.6362
RB2_180 out_180 iv2_180 10073.6084
XU2_180 n4_180 iv2_180 vcc vee out_180 TL084
R1_181 in n1_181 3913.5071
R2_181 n1_181 n2_181 23818.0987
C1_181 n2_181 0 2.121340e-09
C2_181 o1_181 n1_181 3.335397e-09
RA1_181 iv1_181 0 9937.1558
RB1_181 o1_181 iv1_181 9929.9009
XU1_181 n2_181 iv1_181 vcc vee o1_181 TL084
R3_181 o1_181 n3_181 2016.7375
R4_181 n3_181 n4_181 10058.4614
C3_181 n4_181 0 3.427415e-09
C4_181 out_181 n3_181 1.035621e-08
RA2_181 iv2_181 0 10036.8825
RB2_181 out_181 iv2_181 10034.2742
XU2_181 n4_181 iv2_181 vcc vee out_181 TL084
R1_182 in n1_182 3883.4796
R2_182 n1_182 n2_182 23762.5248
C1_182 n2_182 0 2.208777e-09
C2_182 o1_182 n1_182 3.423486e-09
RA1_182 iv1_182 0 10014.8910
RB1_182 o1_182 iv1_182 9936.9537
XU1_182 n2_182 iv1_182 vcc vee o1_182 TL084
R3_182 o1_182 n3_182 2008.4083
R4_182 n3_182 n4_182 9957.0532
C3_182 n4_182 0 3.536267e-09
C4_182 out_182 n3_182 1.090808e-08
RA2_182 iv2_182 0 9929.9161
RB2_182 out_182 iv2_182 9946.6252
XU2_182 n4_182 iv2_182 vcc vee out_182 TL084
R1_183 in n1_183 3900.3884
R2_183 n1_183 n2_183 24168.8549
C1_183 n2_183 0 2.298065e-09
C2_183 o1_183 n1_183 3.533182e-09
RA1_183 iv1_183 0 10012.0505
RB1_183 o1_183 iv1_183 9938.4842
XU1_183 n2_183 iv1_183 vcc vee o1_183 TL084
R3_183 o1_183 n3_183 2018.3860
R4_183 n3_183 n4_183 10009.1410
C3_183 n4_183 0 3.313005e-09
C4_183 out_183 n3_183 9.226687e-09
RA2_183 iv2_183 0 10075.9572
RB2_183 out_183 iv2_183 10052.5825
XU2_183 n4_183 iv2_183 vcc vee out_183 TL084
R1_184 in n1_184 3877.1829
R2_184 n1_184 n2_184 24073.1907
C1_184 n2_184 0 2.068885e-09
C2_184 o1_184 n1_184 3.487387e-09
RA1_184 iv1_184 0 10019.4068
RB1_184 o1_184 iv1_184 10087.6813
XU1_184 n2_184 iv1_184 vcc vee o1_184 TL084
R3_184 o1_184 n3_184 1999.3136
R4_184 n3_184 n4_184 10008.9509
C3_184 n4_184 0 3.009645e-09
C4_184 out_184 n3_184 9.447680e-09
RA2_184 iv2_184 0 9913.9859
RB2_184 out_184 iv2_184 9940.1387
XU2_184 n4_184 iv2_184 vcc vee out_184 TL084
R1_185 in n1_185 3924.4106
R2_185 n1_185 n2_185 23987.4738
C1_185 n2_185 0 2.403313e-09
C2_185 o1_185 n1_185 3.375647e-09
RA1_185 iv1_185 0 10089.3191
RB1_185 o1_185 iv1_185 9978.9750
XU1_185 n2_185 iv1_185 vcc vee o1_185 TL084
R3_185 o1_185 n3_185 1992.8716
R4_185 n3_185 n4_185 10043.6623
C3_185 n4_185 0 3.443827e-09
C4_185 out_185 n3_185 9.716137e-09
RA2_185 iv2_185 0 10086.6388
RB2_185 out_185 iv2_185 10006.5874
XU2_185 n4_185 iv2_185 vcc vee out_185 TL084
R1_186 in n1_186 3930.1096
R2_186 n1_186 n2_186 24148.6582
C1_186 n2_186 0 2.235566e-09
C2_186 o1_186 n1_186 3.110184e-09
RA1_186 iv1_186 0 10050.6922
RB1_186 o1_186 iv1_186 9914.1993
XU1_186 n2_186 iv1_186 vcc vee o1_186 TL084
R3_186 o1_186 n3_186 1989.1242
R4_186 n3_186 n4_186 9970.1281
C3_186 n4_186 0 2.979867e-09
C4_186 out_186 n3_186 1.023273e-08
RA2_186 iv2_186 0 10054.4153
RB2_186 out_186 iv2_186 9931.1234
XU2_186 n4_186 iv2_186 vcc vee out_186 TL084
R1_187 in n1_187 3923.8474
R2_187 n1_187 n2_187 23975.0834
C1_187 n2_187 0 2.344206e-09
C2_187 o1_187 n1_187 3.130224e-09
RA1_187 iv1_187 0 9946.1411
RB1_187 o1_187 iv1_187 9904.6821
XU1_187 n2_187 iv1_187 vcc vee o1_187 TL084
R3_187 o1_187 n3_187 2019.4969
R4_187 n3_187 n4_187 9923.0104
C3_187 n4_187 0 3.405945e-09
C4_187 out_187 n3_187 9.045068e-09
RA2_187 iv2_187 0 10040.5675
RB2_187 out_187 iv2_187 9932.8565
XU2_187 n4_187 iv2_187 vcc vee out_187 TL084
R1_188 in n1_188 3935.5607
R2_188 n1_188 n2_188 23997.8796
C1_188 n2_188 0 2.307457e-09
C2_188 o1_188 n1_188 3.529502e-09
RA1_188 iv1_188 0 10076.5156
RB1_188 o1_188 iv1_188 9963.2463
XU1_188 n2_188 iv1_188 vcc vee o1_188 TL084
R3_188 o1_188 n3_188 1993.0024
R4_188 n3_188 n4_188 9934.3887
C3_188 n4_188 0 3.042361e-09
C4_188 out_188 n3_188 9.800123e-09
RA2_188 iv2_188 0 10084.3467
RB2_188 out_188 iv2_188 10027.7056
XU2_188 n4_188 iv2_188 vcc vee out_188 TL084
R1_189 in n1_189 3894.8853
R2_189 n1_189 n2_189 24063.0356
C1_189 n2_189 0 2.003563e-09
C2_189 o1_189 n1_189 3.593361e-09
RA1_189 iv1_189 0 9952.2558
RB1_189 o1_189 iv1_189 9947.4526
XU1_189 n2_189 iv1_189 vcc vee o1_189 TL084
R3_189 o1_189 n3_189 2015.4870
R4_189 n3_189 n4_189 9904.5531
C3_189 n4_189 0 3.540664e-09
C4_189 out_189 n3_189 9.155579e-09
RA2_189 iv2_189 0 9973.8363
RB2_189 out_189 iv2_189 10095.3353
XU2_189 n4_189 iv2_189 vcc vee out_189 TL084
R1_190 in n1_190 3909.1055
R2_190 n1_190 n2_190 23884.3546
C1_190 n2_190 0 2.316984e-09
C2_190 o1_190 n1_190 3.412125e-09
RA1_190 iv1_190 0 10049.7146
RB1_190 o1_190 iv1_190 9941.2789
XU1_190 n2_190 iv1_190 vcc vee o1_190 TL084
R3_190 o1_190 n3_190 2002.3884
R4_190 n3_190 n4_190 9974.0991
C3_190 n4_190 0 3.397868e-09
C4_190 out_190 n3_190 1.023696e-08
RA2_190 iv2_190 0 9969.9346
RB2_190 out_190 iv2_190 9925.8318
XU2_190 n4_190 iv2_190 vcc vee out_190 TL084
R1_191 in n1_191 3891.6750
R2_191 n1_191 n2_191 24072.6232
C1_191 n2_191 0 2.104834e-09
C2_191 o1_191 n1_191 3.395401e-09
RA1_191 iv1_191 0 10074.3952
RB1_191 o1_191 iv1_191 10025.9204
XU1_191 n2_191 iv1_191 vcc vee o1_191 TL084
R3_191 o1_191 n3_191 2019.2535
R4_191 n3_191 n4_191 9922.9001
C3_191 n4_191 0 3.539827e-09
C4_191 out_191 n3_191 1.006213e-08
RA2_191 iv2_191 0 9919.7997
RB2_191 out_191 iv2_191 9907.4056
XU2_191 n4_191 iv2_191 vcc vee out_191 TL084
R1_192 in n1_192 3926.4373
R2_192 n1_192 n2_192 24043.3848
C1_192 n2_192 0 2.404133e-09
C2_192 o1_192 n1_192 3.275753e-09
RA1_192 iv1_192 0 9998.6712
RB1_192 o1_192 iv1_192 9965.4377
XU1_192 n2_192 iv1_192 vcc vee o1_192 TL084
R3_192 o1_192 n3_192 2003.1445
R4_192 n3_192 n4_192 9905.2376
C3_192 n4_192 0 3.556574e-09
C4_192 out_192 n3_192 9.783701e-09
RA2_192 iv2_192 0 10019.5079
RB2_192 out_192 iv2_192 10027.9204
XU2_192 n4_192 iv2_192 vcc vee out_192 TL084
R1_193 in n1_193 3924.1452
R2_193 n1_193 n2_193 24025.0247
C1_193 n2_193 0 2.129932e-09
C2_193 o1_193 n1_193 3.181652e-09
RA1_193 iv1_193 0 10049.0911
RB1_193 o1_193 iv1_193 9948.8501
XU1_193 n2_193 iv1_193 vcc vee o1_193 TL084
R3_193 o1_193 n3_193 1999.8243
R4_193 n3_193 n4_193 10011.1333
C3_193 n4_193 0 3.319158e-09
C4_193 out_193 n3_193 1.054641e-08
RA2_193 iv2_193 0 10061.2109
RB2_193 out_193 iv2_193 9940.1002
XU2_193 n4_193 iv2_193 vcc vee out_193 TL084
R1_194 in n1_194 3861.2683
R2_194 n1_194 n2_194 23788.9707
C1_194 n2_194 0 2.191441e-09
C2_194 o1_194 n1_194 3.118194e-09
RA1_194 iv1_194 0 9922.5344
RB1_194 o1_194 iv1_194 9981.6916
XU1_194 n2_194 iv1_194 vcc vee o1_194 TL084
R3_194 o1_194 n3_194 2002.7674
R4_194 n3_194 n4_194 10015.1636
C3_194 n4_194 0 3.333299e-09
C4_194 out_194 n3_194 1.090076e-08
RA2_194 iv2_194 0 10044.9452
RB2_194 out_194 iv2_194 10016.3211
XU2_194 n4_194 iv2_194 vcc vee out_194 TL084
R1_195 in n1_195 3885.1828
R2_195 n1_195 n2_195 24031.8871
C1_195 n2_195 0 2.220713e-09
C2_195 o1_195 n1_195 3.198546e-09
RA1_195 iv1_195 0 10044.2422
RB1_195 o1_195 iv1_195 9989.0284
XU1_195 n2_195 iv1_195 vcc vee o1_195 TL084
R3_195 o1_195 n3_195 1996.0530
R4_195 n3_195 n4_195 9975.5415
C3_195 n4_195 0 3.561746e-09
C4_195 out_195 n3_195 1.047153e-08
RA2_195 iv2_195 0 9984.3923
RB2_195 out_195 iv2_195 10037.7069
XU2_195 n4_195 iv2_195 vcc vee out_195 TL084
R1_196 in n1_196 3894.7694
R2_196 n1_196 n2_196 24030.4413
C1_196 n2_196 0 2.339207e-09
C2_196 o1_196 n1_196 3.570705e-09
RA1_196 iv1_196 0 9926.7762
RB1_196 o1_196 iv1_196 9994.6162
XU1_196 n2_196 iv1_196 vcc vee o1_196 TL084
R3_196 o1_196 n3_196 2015.0794
R4_196 n3_196 n4_196 9976.9263
C3_196 n4_196 0 3.260867e-09
C4_196 out_196 n3_196 9.567259e-09
RA2_196 iv2_196 0 10098.9507
RB2_196 out_196 iv2_196 10009.7180
XU2_196 n4_196 iv2_196 vcc vee out_196 TL084
R1_197 in n1_197 3938.2214
R2_197 n1_197 n2_197 24221.6603
C1_197 n2_197 0 2.072928e-09
C2_197 o1_197 n1_197 3.374552e-09
RA1_197 iv1_197 0 10036.2200
RB1_197 o1_197 iv1_197 9962.0460
XU1_197 n2_197 iv1_197 vcc vee o1_197 TL084
R3_197 o1_197 n3_197 2002.7044
R4_197 n3_197 n4_197 10039.2639
C3_197 n4_197 0 3.539084e-09
C4_197 out_197 n3_197 9.344673e-09
RA2_197 iv2_197 0 9971.9735
RB2_197 out_197 iv2_197 10096.2579
XU2_197 n4_197 iv2_197 vcc vee out_197 TL084
R1_198 in n1_198 3899.6880
R2_198 n1_198 n2_198 24145.1848
C1_198 n2_198 0 2.229392e-09
C2_198 o1_198 n1_198 3.497552e-09
RA1_198 iv1_198 0 10019.9009
RB1_198 o1_198 iv1_198 10097.6845
XU1_198 n2_198 iv1_198 vcc vee o1_198 TL084
R3_198 o1_198 n3_198 1983.7689
R4_198 n3_198 n4_198 10034.4570
C3_198 n4_198 0 3.073911e-09
C4_198 out_198 n3_198 9.357428e-09
RA2_198 iv2_198 0 10001.7989
RB2_198 out_198 iv2_198 9964.3531
XU2_198 n4_198 iv2_198 vcc vee out_198 TL084
R1_199 in n1_199 3926.1868
R2_199 n1_199 n2_199 23984.6144
C1_199 n2_199 0 2.184252e-09
C2_199 o1_199 n1_199 3.576253e-09
RA1_199 iv1_199 0 9999.6270
RB1_199 o1_199 iv1_199 9930.3428
XU1_199 n2_199 iv1_199 vcc vee o1_199 TL084
R3_199 o1_199 n3_199 2009.1591
R4_199 n3_199 n4_199 9982.0993
C3_199 n4_199 0 3.430286e-09
C4_199 out_199 n3_199 9.664624e-09
RA2_199 iv2_199 0 10039.7140
RB2_199 out_199 iv2_199 10005.7423
XU2_199 n4_199 iv2_199 vcc vee out_199 TL084
.control
set wr_vecnames
set wr_singlescale
ac dec 250 100 100k
wrdata mc_c10.dat vdb(out_0) vdb(out_1) vdb(out_2) vdb(out_3) vdb(out_4) vdb(out_5) vdb(out_6) vdb(out_7) vdb(out_8) vdb(out_9) vdb(out_10) vdb(out_11) vdb(out_12) vdb(out_13) vdb(out_14) vdb(out_15) vdb(out_16) vdb(out_17) vdb(out_18) vdb(out_19) vdb(out_20) vdb(out_21) vdb(out_22) vdb(out_23) vdb(out_24) vdb(out_25) vdb(out_26) vdb(out_27) vdb(out_28) vdb(out_29) vdb(out_30) vdb(out_31) vdb(out_32) vdb(out_33) vdb(out_34) vdb(out_35) vdb(out_36) vdb(out_37) vdb(out_38) vdb(out_39) vdb(out_40) vdb(out_41) vdb(out_42) vdb(out_43) vdb(out_44) vdb(out_45) vdb(out_46) vdb(out_47) vdb(out_48) vdb(out_49) vdb(out_50) vdb(out_51) vdb(out_52) vdb(out_53) vdb(out_54) vdb(out_55) vdb(out_56) vdb(out_57) vdb(out_58) vdb(out_59) vdb(out_60) vdb(out_61) vdb(out_62) vdb(out_63) vdb(out_64) vdb(out_65) vdb(out_66) vdb(out_67) vdb(out_68) vdb(out_69) vdb(out_70) vdb(out_71) vdb(out_72) vdb(out_73) vdb(out_74) vdb(out_75) vdb(out_76) vdb(out_77) vdb(out_78) vdb(out_79) vdb(out_80) vdb(out_81) vdb(out_82) vdb(out_83) vdb(out_84) vdb(out_85) vdb(out_86) vdb(out_87) vdb(out_88) vdb(out_89) vdb(out_90) vdb(out_91) vdb(out_92) vdb(out_93) vdb(out_94) vdb(out_95) vdb(out_96) vdb(out_97) vdb(out_98) vdb(out_99) vdb(out_100) vdb(out_101) vdb(out_102) vdb(out_103) vdb(out_104) vdb(out_105) vdb(out_106) vdb(out_107) vdb(out_108) vdb(out_109) vdb(out_110) vdb(out_111) vdb(out_112) vdb(out_113) vdb(out_114) vdb(out_115) vdb(out_116) vdb(out_117) vdb(out_118) vdb(out_119) vdb(out_120) vdb(out_121) vdb(out_122) vdb(out_123) vdb(out_124) vdb(out_125) vdb(out_126) vdb(out_127) vdb(out_128) vdb(out_129) vdb(out_130) vdb(out_131) vdb(out_132) vdb(out_133) vdb(out_134) vdb(out_135) vdb(out_136) vdb(out_137) vdb(out_138) vdb(out_139) vdb(out_140) vdb(out_141) vdb(out_142) vdb(out_143) vdb(out_144) vdb(out_145) vdb(out_146) vdb(out_147) vdb(out_148) vdb(out_149) vdb(out_150) vdb(out_151) vdb(out_152) vdb(out_153) vdb(out_154) vdb(out_155) vdb(out_156) vdb(out_157) vdb(out_158) vdb(out_159) vdb(out_160) vdb(out_161) vdb(out_162) vdb(out_163) vdb(out_164) vdb(out_165) vdb(out_166) vdb(out_167) vdb(out_168) vdb(out_169) vdb(out_170) vdb(out_171) vdb(out_172) vdb(out_173) vdb(out_174) vdb(out_175) vdb(out_176) vdb(out_177) vdb(out_178) vdb(out_179) vdb(out_180) vdb(out_181) vdb(out_182) vdb(out_183) vdb(out_184) vdb(out_185) vdb(out_186) vdb(out_187) vdb(out_188) vdb(out_189) vdb(out_190) vdb(out_191) vdb(out_192) vdb(out_193) vdb(out_194) vdb(out_195) vdb(out_196) vdb(out_197) vdb(out_198) vdb(out_199)
quit
.endc
.END
